************************************************************************
* auCdl Netlist:
*
* Library Name:  BJ_IF_TSMCN28_PHY_SCH_V100
* Top Cell Name: hb_macro_bnk_230m_4s_sample
* View Name:     schematic
* Netlisted on:  Aug 19 17:29:35 2025
************************************************************************

*.BIPOLAR
*.RESI = 2000
*.RESVAL
*.CAPVAL
*.DIOPERI
*.DIOAREA
*.EQUATION
*.SCALE METER
*.MEGA
.PARAM

************************************************************************
* Library Name: BJ_IF_TSMCN28_PHY_SCH_V100
* Cell Name:    BUFFD6BWP7T30P140
* View Name:    schematic
************************************************************************

.SUBCKT BUFFD6BWP7T30P140 I VDD VSS Z
*.PININFO I:B VDD:B VSS:B Z:B
MMM0 Z net9 VSS VSS nch_mac l=30n w=200n m=1 nf=1
MMM0_2 Z net9 VSS VSS nch_mac l=30n w=200n m=1 nf=1
MMM0_3 Z net9 VSS VSS nch_mac l=30n w=200n m=1 nf=1
MMM0_4 Z net9 VSS VSS nch_mac l=30n w=200n m=1 nf=1
MMM0_5 Z net9 VSS VSS nch_mac l=30n w=200n m=1 nf=1
MMM0_6 Z net9 VSS VSS nch_mac l=30n w=200n m=1 nf=1
MMM5 net9 I VSS VSS nch_mac l=30n w=200n m=1 nf=1
MMM5_2 net9 I VSS VSS nch_mac l=30n w=200n m=1 nf=1
MMM1 Z net9 VDD VDD pch_mac l=30n w=220.0n m=1 nf=1
MMM1_2 Z net9 VDD VDD pch_mac l=30n w=220.0n m=1 nf=1
MMM1_3 Z net9 VDD VDD pch_mac l=30n w=220.0n m=1 nf=1
MMM1_4 Z net9 VDD VDD pch_mac l=30n w=220.0n m=1 nf=1
MMM1_5 Z net9 VDD VDD pch_mac l=30n w=220.0n m=1 nf=1
MMM1_6 Z net9 VDD VDD pch_mac l=30n w=220.0n m=1 nf=1
MMM4 net9 I VDD VDD pch_mac l=30n w=220.0n m=1 nf=1
MMM4_2 net9 I VDD VDD pch_mac l=30n w=220.0n m=1 nf=1
.ENDS

************************************************************************
* Library Name: BJ_IF_TSMCN28_PHY_SCH_V100
* Cell Name:    and_array
* View Name:    schematic
************************************************************************

.SUBCKT and_array A B Z vdd_array vss_array
*.PININFO A:I B:I Z:O vdd_array:B vss_array:B
MNM1 Z net35 vss_array vss_array nch_18ud12_mac l=90n w=1.6u m=1 nf=1
MNM2 net35 A net37 vss_array nch_18ud12_mac l=90n w=800n m=1 nf=1
MNM0 net37 B vss_array vss_array nch_18ud12_mac l=90n w=800n m=1 nf=1
MPM2 Z net35 vdd_array vdd_array pch_18ud12_mac l=90n w=1.6u m=1 nf=1
MPM1 net35 B vdd_array vdd_array pch_18ud12_mac l=90n w=800n m=1 nf=1
MPM0 net35 A vdd_array vdd_array pch_18ud12_mac l=90n w=800n m=1 nf=1
.ENDS

************************************************************************
* Library Name: BJ_IF_TSMCN28_PHY_SCH_V100
* Cell Name:    BUFFD4BWP7T30P140
* View Name:    schematic
************************************************************************

.SUBCKT BUFFD4BWP7T30P140 I VDD VSS Z
*.PININFO I:B VDD:B VSS:B Z:B
MMM0 Z net9 VSS VSS nch_mac l=30n w=200n m=1 nf=1
MMM0_2 Z net9 VSS VSS nch_mac l=30n w=200n m=1 nf=1
MMM0_3 Z net9 VSS VSS nch_mac l=30n w=200n m=1 nf=1
MMM0_4 Z net9 VSS VSS nch_mac l=30n w=200n m=1 nf=1
MMM5 net9 I VSS VSS nch_mac l=30n w=200n m=1 nf=1
MMM5_2 net9 I VSS VSS nch_mac l=30n w=200n m=1 nf=1
MMM1 Z net9 VDD VDD pch_mac l=30n w=220.0n m=1 nf=1
MMM1_2 Z net9 VDD VDD pch_mac l=30n w=220.0n m=1 nf=1
MMM1_3 Z net9 VDD VDD pch_mac l=30n w=220.0n m=1 nf=1
MMM1_4 Z net9 VDD VDD pch_mac l=30n w=220.0n m=1 nf=1
MMM4 net9 I VDD VDD pch_mac l=30n w=220.0n m=1 nf=1
MMM4_2 net9 I VDD VDD pch_mac l=30n w=220.0n m=1 nf=1
.ENDS

************************************************************************
* Library Name: BJ_IF_TSMCN28_PHY_SCH_V100
* Cell Name:    DFSNQD1BWP7T30P140
* View Name:    schematic
************************************************************************

.SUBCKT DFSNQD1BWP7T30P140 CP D Q SDN VDD VSS
*.PININFO CP:B D:B Q:B SDN:B VDD:B VSS:B
MMM44 net103 D VDD VDD pch_mac l=30n w=220.0n m=1 nf=1
MMM45 mq_x clkbb net103 VDD pch_mac l=30n w=120.0n m=1 nf=1
MMM61 net0225 mq VDD VDD pch_mac l=30n w=110.0n m=1 nf=1
MMM5 mq_x clkb net0225 VDD pch_mac l=30n w=110.0n m=1 nf=1
MMM72 Q qf_x VDD VDD pch_mac l=30n w=220.0n m=1 nf=1
MMM54 clkb CP VDD VDD pch_mac l=30n w=220.0n m=1 nf=1
MMM56 clkbb clkb VDD VDD pch_mac l=30n w=220.0n m=1 nf=1
MMM50 mq mq_x VDD VDD pch_mac l=30n w=210.0n m=1 nf=1
MMSLTp1 qf clkb mq VDD pch_mac l=30n w=210.0n m=1 nf=1
MMM77 qf_x qf VDD VDD pch_mac l=30n w=220.0n m=1 nf=1
MMM74 net172 qf_x VDD VDD pch_mac l=30n w=110.0n m=1 nf=1
MMM68 net172 clkbb qf VDD pch_mac l=30n w=115.00n m=1 nf=1
MMM3 net172 SDN VDD VDD pch_mac l=30n w=110.0n m=1 nf=1
MMM1 mq SDN VDD VDD pch_mac l=30n w=110.0n m=1 nf=1
MMM47 net212 D VSS VSS nch_mac l=30n w=200n m=1 nf=1
MMM46 mq_x clkb net212 VSS nch_mac l=30n w=130.0n m=1 nf=1
MMM67 net0144 clkb qf VSS nch_mac l=3e-08 w=100n m=1 nf=1
MMM73 net0144 SDN net0176 VSS nch_mac l=3e-08 w=100n m=1 nf=1
MMM2 net0176 qf_x VSS VSS nch_mac l=3e-08 w=100n m=1 nf=1
MMM4 mq_x clkbb net0155 VSS nch_mac l=3e-08 w=100n m=1 nf=1
MMM66 net0155 mq VSS VSS nch_mac l=3e-08 w=100n m=1 nf=1
MMM0 net0162 mq_x VSS VSS nch_mac l=30n w=200n m=1 nf=1
MMM49 mq SDN net0162 VSS nch_mac l=30n w=200n m=1 nf=1
MMM71 Q qf_x VSS VSS nch_mac l=30n w=200n m=1 nf=1
MMM53 clkb CP VSS VSS nch_mac l=30n w=200n m=1 nf=1
MMM55 clkbb clkb VSS VSS nch_mac l=30n w=200n m=1 nf=1
MMSLTn1 qf clkbb mq VSS nch_mac l=30n w=140.0n m=1 nf=1
MMM76 qf_x qf VSS VSS nch_mac l=30n w=200n m=1 nf=1
.ENDS

************************************************************************
* Library Name: BJ_IF_TSMCN28_PHY_SCH_V100
* Cell Name:    TIEHBWP7T30P140
* View Name:    schematic
************************************************************************

.SUBCKT TIEHBWP7T30P140 VDD VSS Z
*.PININFO VDD:B VSS:B Z:B
MMM8 net10 net10 VSS VSS nch_mac l=30n w=200n m=1 nf=1
MMM5 Z net10 VDD VDD pch_mac l=30n w=220.0n m=1 nf=1
.ENDS

************************************************************************
* Library Name: BJ_IF_TSMCN28_PHY_SCH_V100
* Cell Name:    INVD2BWP7T30P140
* View Name:    schematic
************************************************************************

.SUBCKT INVD2BWP7T30P140 I VDD VSS ZN
*.PININFO I:B VDD:B VSS:B ZN:B
MMM1 ZN I VSS VSS nch_mac l=30n w=200n m=1 nf=1
MMM1_2 ZN I VSS VSS nch_mac l=30n w=200n m=1 nf=1
MMM0 ZN I VDD VDD pch_mac l=30n w=220.0n m=1 nf=1
MMM0_2 ZN I VDD VDD pch_mac l=30n w=220.0n m=1 nf=1
.ENDS

************************************************************************
* Library Name: BJ_IF_TSMCN28_PHY_SCH_V100
* Cell Name:    Levelshift_1p1
* View Name:    schematic
************************************************************************

.SUBCKT Levelshift_1p1 D DVDD DVSS D_ls VDD VSS
*.PININFO D:I D_ls:O DVDD:B DVSS:B VDD:B VSS:B
Xi3 D VDD VSS D_n / INVD2BWP7T30P140
MN1 net5 D DVSS DVSS nch_18ud12_mac l=90n w=1.6u m=2 nf=1
MN2 D_ls D_n DVSS DVSS nch_18ud12_mac l=90n w=1.6u m=2 nf=1
MP2 net13 net5 DVDD DVDD pch_18ud12_mac l=90n w=1.6u m=2 nf=1
MP3 net5 D net14 DVDD pch_18ud12_mac l=90n w=1.6u m=2 nf=1
MP1 net14 D_ls DVDD DVDD pch_18ud12_mac l=90n w=1.6u m=2 nf=1
MP4 D_ls D_n net13 DVDD pch_18ud12_mac l=90n w=1.6u m=2 nf=1
.ENDS

************************************************************************
* Library Name: BJ_IF_TSMCN28_PHY_SCH_V100
* Cell Name:    Levelshift_1p1buf_nom
* View Name:    schematic
************************************************************************

.SUBCKT Levelshift_1p1buf_nom DVDD DVSS Din Dout VDD VSS
*.PININFO Din:I Dout:O DVDD:B DVSS:B VDD:B VSS:B
MM1 D_ls_b D_ls DVDD DVDD pch_18ud12_mac l=90n w=1.6u m=1 nf=1
MM2 Dout D_ls_b DVDD DVDD pch_18ud12_mac l=90n w=1.6u m=10 nf=1
MM0 D_ls_b D_ls DVSS DVSS nch_18ud12_mac l=90n w=1.6u m=1 nf=1
MM3 Dout D_ls_b DVSS DVSS nch_18ud12_mac l=90n w=1.6u m=8 nf=1
XI3 Din DVDD DVSS D_ls VDD VSS / Levelshift_1p1
.ENDS

************************************************************************
* Library Name: BJ_IF_TSMCN28_PHY_SCH_V100
* Cell Name:    BUFFD3BWP7T30P140
* View Name:    schematic
************************************************************************

.SUBCKT BUFFD3BWP7T30P140 I VDD VSS Z
*.PININFO I:B VDD:B VSS:B Z:B
MMM5 net9 I VSS VSS nch_mac l=30n w=200n m=1 nf=1
MMM0 Z net9 VSS VSS nch_mac l=30n w=200n m=1 nf=1
MMM0_2 Z net9 VSS VSS nch_mac l=30n w=200n m=1 nf=1
MMM0_3 Z net9 VSS VSS nch_mac l=30n w=200n m=1 nf=1
MMM4 net9 I VDD VDD pch_mac l=30n w=220.0n m=1 nf=1
MMM1 Z net9 VDD VDD pch_mac l=30n w=220.0n m=1 nf=1
MMM1_2 Z net9 VDD VDD pch_mac l=30n w=220.0n m=1 nf=1
MMM1_3 Z net9 VDD VDD pch_mac l=30n w=220.0n m=1 nf=1
.ENDS

************************************************************************
* Library Name: BJ_IF_TSMCN28_PHY_SCH_V100
* Cell Name:    BUFFD2BWP7T30P140
* View Name:    schematic
************************************************************************

.SUBCKT BUFFD2BWP7T30P140 I VDD VSS Z
*.PININFO I:B VDD:B VSS:B Z:B
MMM5 net9 I VSS VSS nch_mac l=30n w=200n m=1 nf=1
MMM0 Z net9 VSS VSS nch_mac l=30n w=200n m=1 nf=1
MMM0_2 Z net9 VSS VSS nch_mac l=30n w=200n m=1 nf=1
MMM4 net9 I VDD VDD pch_mac l=30n w=220.0n m=1 nf=1
MMM1 Z net9 VDD VDD pch_mac l=30n w=220.0n m=1 nf=1
MMM1_2 Z net9 VDD VDD pch_mac l=30n w=220.0n m=1 nf=1
.ENDS

************************************************************************
* Library Name: BJ_IF_TSMCN28_PHY_SCH_V100
* Cell Name:    BUF_DLY
* View Name:    schematic
************************************************************************

.SUBCKT BUF_DLY A VDDR VSS X
*.PININFO A:I X:O VDDR:B VSS:B
Xi6 net2 VDDR VSS net9 / BUFFD2BWP7T30P140
Xi5 net9 VDDR VSS X / BUFFD2BWP7T30P140
Xi0 A VDDR VSS net1 / BUFFD2BWP7T30P140
Xi1 net1 VDDR VSS net2 / BUFFD2BWP7T30P140
.ENDS

************************************************************************
* Library Name: BJ_IF_TSMCN28_PHY_SCH_V100
* Cell Name:    dly_unit
* View Name:    schematic
************************************************************************

.SUBCKT dly_unit A Y vdd vss
*.PININFO A:I vdd:I vss:I Y:O
Xi26 net015 vdd vss net018 / BUF_DLY
Xi10 A vdd vss net016 / BUF_DLY
Xi27 net018 vdd vss Y / BUF_DLY
Xi25 net016 vdd vss net015 / BUF_DLY
.ENDS

************************************************************************
* Library Name: BJ_IF_TSMCN28_PHY_SCH_V100
* Cell Name:    phy_trinv
* View Name:    schematic
************************************************************************

.SUBCKT phy_trinv A EN ENB VDD VSS Y
*.PININFO A:I EN:I ENB:I VDD:B VSS:B Y:B
MNM0 Y EN net011 VSS nch_mac l=30n w=200n m=1 nf=1
MNM1 net011 A VSS VSS nch_mac l=30n w=200n m=1 nf=1
MPM0 net010 A VDD VDD pch_mac l=30n w=220.0n m=1 nf=1
MPM1 Y ENB net010 VDD pch_mac l=30n w=220.0n m=1 nf=1
.ENDS

************************************************************************
* Library Name: BJ_IF_TSMCN28_PHY_SCH_V100
* Cell Name:    hb_macro_dly
* View Name:    schematic
************************************************************************

.SUBCKT hb_macro_dly A Y cfg_sel_0 cfg_sel_0_n cfg_sel_1 cfg_sel_1_n cfg_sel_2
+ cfg_sel_2_n cfg_sel_3 cfg_sel_3_n vdd vss
*.PININFO A:I cfg_sel_0:I cfg_sel_0_n:I cfg_sel_1:I cfg_sel_1_n:I cfg_sel_2:I
*.PININFO cfg_sel_2_n:I cfg_sel_3:I cfg_sel_3_n:I vdd:I vss:I Y:O
Xi21 A dly1 vdd vss / dly_unit
Xi30 dly2 dly3 vdd vss / dly_unit
Xi29 dly1 dly2 vdd vss / dly_unit
Xsel_0 A cfg_sel_0 cfg_sel_0_n vdd vss to_array_n / phy_trinv
Xsel_3 dly3 cfg_sel_3 cfg_sel_3_n vdd vss to_array_n / phy_trinv
Xsel_2 dly2 cfg_sel_2 cfg_sel_2_n vdd vss to_array_n / phy_trinv
Xsel_1 dly1 cfg_sel_1 cfg_sel_1_n vdd vss to_array_n / phy_trinv
Xi24 to_array_n vdd vss Y / INVD2BWP7T30P140
.ENDS

************************************************************************
* Library Name: BJ_IF_TSMCN28_PHY_SCH_V100
* Cell Name:    BUFFD16BWP7T30P140
* View Name:    schematic
************************************************************************

.SUBCKT BUFFD16BWP7T30P140 I VDD VSS Z
*.PININFO I:B VDD:B VSS:B Z:B
MMM0 Z net9 VSS VSS nch_mac l=30n w=200n m=1 nf=1
MMM0_2 Z net9 VSS VSS nch_mac l=30n w=200n m=1 nf=1
MMM0_3 Z net9 VSS VSS nch_mac l=30n w=200n m=1 nf=1
MMM0_4 Z net9 VSS VSS nch_mac l=30n w=200n m=1 nf=1
MMM0_5 Z net9 VSS VSS nch_mac l=30n w=200n m=1 nf=1
MMM0_6 Z net9 VSS VSS nch_mac l=30n w=200n m=1 nf=1
MMM0_7 Z net9 VSS VSS nch_mac l=30n w=200n m=1 nf=1
MMM0_8 Z net9 VSS VSS nch_mac l=30n w=200n m=1 nf=1
MMM0_9 Z net9 VSS VSS nch_mac l=30n w=200n m=1 nf=1
MMM0_10 Z net9 VSS VSS nch_mac l=30n w=200n m=1 nf=1
MMM0_11 Z net9 VSS VSS nch_mac l=30n w=200n m=1 nf=1
MMM0_12 Z net9 VSS VSS nch_mac l=30n w=200n m=1 nf=1
MMM0_13 Z net9 VSS VSS nch_mac l=30n w=200n m=1 nf=1
MMM0_14 Z net9 VSS VSS nch_mac l=30n w=200n m=1 nf=1
MMM0_15 Z net9 VSS VSS nch_mac l=30n w=200n m=1 nf=1
MMM0_16 Z net9 VSS VSS nch_mac l=30n w=200n m=1 nf=1
MMM5 net9 I VSS VSS nch_mac l=30n w=200n m=1 nf=1
MMM5_2 net9 I VSS VSS nch_mac l=30n w=200n m=1 nf=1
MMM5_3 net9 I VSS VSS nch_mac l=30n w=200n m=1 nf=1
MMM5_4 net9 I VSS VSS nch_mac l=30n w=200n m=1 nf=1
MMM5_5 net9 I VSS VSS nch_mac l=30n w=200n m=1 nf=1
MMM1 Z net9 VDD VDD pch_mac l=30n w=220.0n m=1 nf=1
MMM1_2 Z net9 VDD VDD pch_mac l=30n w=220.0n m=1 nf=1
MMM1_3 Z net9 VDD VDD pch_mac l=30n w=220.0n m=1 nf=1
MMM1_4 Z net9 VDD VDD pch_mac l=30n w=220.0n m=1 nf=1
MMM1_5 Z net9 VDD VDD pch_mac l=30n w=220.0n m=1 nf=1
MMM1_6 Z net9 VDD VDD pch_mac l=30n w=220.0n m=1 nf=1
MMM1_7 Z net9 VDD VDD pch_mac l=30n w=220.0n m=1 nf=1
MMM1_8 Z net9 VDD VDD pch_mac l=30n w=220.0n m=1 nf=1
MMM1_9 Z net9 VDD VDD pch_mac l=30n w=220.0n m=1 nf=1
MMM1_10 Z net9 VDD VDD pch_mac l=30n w=220.0n m=1 nf=1
MMM1_11 Z net9 VDD VDD pch_mac l=30n w=220.0n m=1 nf=1
MMM1_12 Z net9 VDD VDD pch_mac l=30n w=220.0n m=1 nf=1
MMM1_13 Z net9 VDD VDD pch_mac l=30n w=220.0n m=1 nf=1
MMM1_14 Z net9 VDD VDD pch_mac l=30n w=220.0n m=1 nf=1
MMM1_15 Z net9 VDD VDD pch_mac l=30n w=220.0n m=1 nf=1
MMM1_16 Z net9 VDD VDD pch_mac l=30n w=220.0n m=1 nf=1
MMM4 net9 I VDD VDD pch_mac l=30n w=220.0n m=1 nf=1
MMM4_2 net9 I VDD VDD pch_mac l=30n w=220.0n m=1 nf=1
MMM4_3 net9 I VDD VDD pch_mac l=30n w=220.0n m=1 nf=1
MMM4_4 net9 I VDD VDD pch_mac l=30n w=220.0n m=1 nf=1
MMM4_5 net9 I VDD VDD pch_mac l=30n w=220.0n m=1 nf=1
.ENDS

************************************************************************
* Library Name: BJ_IF_TSMCN28_PHY_SCH_V100
* Cell Name:    BUFFD8BWP7T30P140
* View Name:    schematic
************************************************************************

.SUBCKT BUFFD8BWP7T30P140 I VDD VSS Z
*.PININFO I:B VDD:B VSS:B Z:B
MMM0 Z net9 VSS VSS nch_mac l=30n w=200n m=1 nf=1
MMM0_2 Z net9 VSS VSS nch_mac l=30n w=200n m=1 nf=1
MMM0_3 Z net9 VSS VSS nch_mac l=30n w=200n m=1 nf=1
MMM0_4 Z net9 VSS VSS nch_mac l=30n w=200n m=1 nf=1
MMM0_5 Z net9 VSS VSS nch_mac l=30n w=200n m=1 nf=1
MMM0_6 Z net9 VSS VSS nch_mac l=30n w=200n m=1 nf=1
MMM0_7 Z net9 VSS VSS nch_mac l=30n w=200n m=1 nf=1
MMM0_8 Z net9 VSS VSS nch_mac l=30n w=200n m=1 nf=1
MMM5 net9 I VSS VSS nch_mac l=30n w=200n m=1 nf=1
MMM5_2 net9 I VSS VSS nch_mac l=30n w=200n m=1 nf=1
MMM5_3 net9 I VSS VSS nch_mac l=30n w=200n m=1 nf=1
MMM1 Z net9 VDD VDD pch_mac l=30n w=220.0n m=1 nf=1
MMM1_2 Z net9 VDD VDD pch_mac l=30n w=220.0n m=1 nf=1
MMM1_3 Z net9 VDD VDD pch_mac l=30n w=220.0n m=1 nf=1
MMM1_4 Z net9 VDD VDD pch_mac l=30n w=220.0n m=1 nf=1
MMM1_5 Z net9 VDD VDD pch_mac l=30n w=220.0n m=1 nf=1
MMM1_6 Z net9 VDD VDD pch_mac l=30n w=220.0n m=1 nf=1
MMM1_7 Z net9 VDD VDD pch_mac l=30n w=220.0n m=1 nf=1
MMM1_8 Z net9 VDD VDD pch_mac l=30n w=220.0n m=1 nf=1
MMM4 net9 I VDD VDD pch_mac l=30n w=220.0n m=1 nf=1
MMM4_2 net9 I VDD VDD pch_mac l=30n w=220.0n m=1 nf=1
MMM4_3 net9 I VDD VDD pch_mac l=30n w=220.0n m=1 nf=1
.ENDS

************************************************************************
* Library Name: BJ_IF_TSMCN28_PHY_SCH_V100
* Cell Name:    level_shift_p2
* View Name:    schematic
************************************************************************

.SUBCKT level_shift_p2 D_in en out vdd vdd_array vss vss_array
*.PININFO D_in:I en:I out:O vdd:B vdd_array:B vss:B vss_array:B
MNM2 D_nand D_in net073 vss_array nch_18ud12_mac l=90n w=1.6u m=2 nf=1
MNM0 net073 en vss_array vss_array nch_18ud12_mac l=90n w=1.6u m=2 nf=1
MNM1 D_ls D_nand vss vss nch_18ud12_mac l=90n w=1.6u m=1 nf=1
MPM2 D_ls D_nand vdd vdd pch_18ud12_mac l=90n w=1.6u m=1 nf=1
MPM1 D_nand en vdd_array vdd_array pch_18ud12_mac l=90n w=1.6u m=1 nf=1
MPM0 D_nand D_in vdd_array vdd_array pch_18ud12_mac l=90n w=1.6u m=1 nf=1
Xi2 D_ls vdd vss out / BUFFD4BWP7T30P140
CC0 out vss 10f $[CP]
.ENDS

************************************************************************
* Library Name: BJ_IF_TSMCN28_PHY_SCH_V100
* Cell Name:    asic_in_p2
* View Name:    schematic
************************************************************************

.SUBCKT asic_in_p2 A LS_en Y vdd vdd_array vss vss_array
*.PININFO A:I LS_en:I vdd:I vdd_array:I vss:I vss_array:I Y:O
Xi4 net7 vdd vss Y / BUFFD8BWP7T30P140
Xi6 net7 vdd vss Y / BUFFD8BWP7T30P140
Xi3 net7 vdd vss Y / BUFFD8BWP7T30P140
Xi5 A LS_en net7 vdd vdd_array vss vss_array / level_shift_p2
.ENDS

************************************************************************
* Library Name: BJ_IF_TSMCN28_PHY_SCH_V100
* Cell Name:    phy_latch_inv_hv_x1p5_v3
* View Name:    schematic
************************************************************************

.SUBCKT phy_latch_inv_hv_x1p5_v3 A VDD_ARRAY VSS_ARRAY Y
*.PININFO A:I Y:O VDD_ARRAY:B VSS_ARRAY:B
MPM0 Y A VDD_ARRAY VDD_ARRAY pch_18ud12_mac l=90n w=800n m=1 nf=1
MNM0 Y A VSS_ARRAY VSS_ARRAY nch_18ud12_mac l=90n w=400n m=2 nf=1
.ENDS

************************************************************************
* Library Name: BJ_IF_TSMCN28_PHY_SCH_V100
* Cell Name:    GINVD4BWP7T30P140
* View Name:    schematic
************************************************************************

.SUBCKT GINVD4BWP7T30P140 I VDD VSS ZN
*.PININFO I:B VDD:B VSS:B ZN:B
MMM1 ZN I VSS VSS nch_mac l=30n w=200n m=1 nf=1
MMM1_2 ZN I VSS VSS nch_mac l=30n w=200n m=1 nf=1
MMM1_3 ZN I VSS VSS nch_mac l=30n w=200n m=1 nf=1
MMM1_4 ZN I VSS VSS nch_mac l=30n w=200n m=1 nf=1
MMM0 ZN I VDD VDD pch_mac l=30n w=220.0n m=1 nf=1
MMM0_2 ZN I VDD VDD pch_mac l=30n w=220.0n m=1 nf=1
MMM0_3 ZN I VDD VDD pch_mac l=30n w=220.0n m=1 nf=1
MMM0_4 ZN I VDD VDD pch_mac l=30n w=220.0n m=1 nf=1
.ENDS

************************************************************************
* Library Name: BJ_IF_TSMCN28_PHY_SCH_V100
* Cell Name:    Levelshift_1p1_fast
* View Name:    schematic
************************************************************************

.SUBCKT Levelshift_1p1_fast D DVDD DVSS D_ls VDD VSS
*.PININFO D:I D_ls:O DVDD:B DVSS:B VDD:B VSS:B
Xi3 D VDD VSS D_n / GINVD4BWP7T30P140
MP2 net3 net1 DVDD DVDD pch_18ud12_mac l=90n w=1.6u m=2 nf=1
MP1 net2 D_ls DVDD DVDD pch_18ud12_mac l=90n w=1.6u m=2 nf=1
MP3 net1 D net2 DVDD pch_18ud12_mac l=90n w=1.6u m=2 nf=1
MP4 D_ls D_n net3 DVDD pch_18ud12_mac l=90n w=1.6u m=2 nf=1
MN1 net1 D DVSS DVSS nch_18ud12_mac l=90n w=1.6u m=2 nf=1
MN2 D_ls D_n DVSS DVSS nch_18ud12_mac l=90n w=1.6u m=2 nf=1
.ENDS

************************************************************************
* Library Name: BJ_IF_TSMCN28_PHY_SCH_V100
* Cell Name:    levelshift_1p1en_P2
* View Name:    schematic
************************************************************************

.SUBCKT levelshift_1p1en_P2 DVDD DVSS Din Dout VDD VSS en enb
*.PININFO Din:I en:I enb:I Dout:O DVDD:B DVSS:B VDD:B VSS:B
MPM2 net012 D_ls DVDD DVDD pch_18ud12_mac l=90n w=1.6u m=2 nf=1
MPM0 D_ls_nand D_ls DVDD DVDD pch_18ud12_mac l=90n w=1u m=1 nf=1
MPM4 D_ls_nor enb net012 DVDD pch_18ud12_mac l=90n w=1.6u m=2 nf=1
MPM3 Dout D_ls_nand DVDD DVDD pch_18ud12_mac l=90n w=1.6u m=18 nf=1
MPM1 D_ls_nand en DVDD DVDD pch_18ud12_mac l=90n w=400n m=1 nf=1
Xi0 Din DVDD DVSS D_ls VDD VSS / Levelshift_1p1_fast
MNM4 D_ls_nor D_ls DVSS DVSS nch_18ud12_mac l=90n w=1.6u m=2 nf=1
MNM2 Dout D_ls_nor DVSS DVSS nch_18ud12_mac l=90n w=1.6u m=8 nf=1
MNM3 D_ls_nor enb DVSS DVSS nch_18ud12_mac l=90n w=400n m=1 nf=1
MNM0 D_ls_nand en net2 DVSS nch_18ud12_mac l=90n w=1.6u m=2 nf=1
MNM1 net2 D_ls DVSS DVSS nch_18ud12_mac l=90n w=1.6u m=2 nf=1
MM0 DVSS DVSS DVSS DVSS nch_18ud12_mac l=90n w=1.6u m=2 nf=1
.ENDS

************************************************************************
* Library Name: BJ_IF_TSMCN28_PHY_SCH_V100
* Cell Name:    GINVD2BWP7T30P140
* View Name:    schematic
************************************************************************

.SUBCKT GINVD2BWP7T30P140 I VDD VSS ZN
*.PININFO I:B VDD:B VSS:B ZN:B
MMM1 ZN I VSS VSS nch_mac l=30n w=200n m=1 nf=1
MMM1_2 ZN I VSS VSS nch_mac l=30n w=200n m=1 nf=1
MMM0 ZN I VDD VDD pch_mac l=30n w=220.0n m=1 nf=1
MMM0_2 ZN I VDD VDD pch_mac l=30n w=220.0n m=1 nf=1
.ENDS

************************************************************************
* Library Name: BJ_IF_TSMCN28_PHY_SCH_V100
* Cell Name:    Levelshift_1p1_small
* View Name:    schematic
************************************************************************

.SUBCKT Levelshift_1p1_small D DVDD DVSS D_ls D_ls_n VDD VSS
*.PININFO D:I D_ls:O D_ls_n:O DVDD:B DVSS:B VDD:B VSS:B
MN1 D_ls_n D DVSS DVSS nch_18ud12_mac l=90n w=1.6u m=1 nf=1
MN2 D_ls D_n DVSS DVSS nch_18ud12_mac l=90n w=1.6u m=1 nf=1
MP2 net13 D_ls_n DVDD DVDD pch_18ud12_mac l=90n w=1.6u m=1 nf=1
MP3 D_ls_n D net14 DVDD pch_18ud12_mac l=90n w=1.6u m=1 nf=1
MP1 net14 D_ls DVDD DVDD pch_18ud12_mac l=90n w=1.6u m=1 nf=1
MP4 D_ls D_n net13 DVDD pch_18ud12_mac l=90n w=1.6u m=1 nf=1
Xi3 D VDD VSS D_n / GINVD2BWP7T30P140
.ENDS

************************************************************************
* Library Name: BJ_IF_TSMCN28_PHY_SCH_V100
* Cell Name:    phy_latch_inv_hv_x1_v3
* View Name:    schematic
************************************************************************

.SUBCKT phy_latch_inv_hv_x1_v3 A VDD_ARRAY VSS_ARRAY Y
*.PININFO A:I Y:O VDD_ARRAY:B VSS_ARRAY:B
MPM0 Y A VDD_ARRAY VDD_ARRAY pch_18ud12_mac l=90n w=400n m=2 nf=1
MNM0 Y A VSS_ARRAY VSS_ARRAY nch_18ud12_mac l=90n w=400n m=1 nf=1
.ENDS

************************************************************************
* Library Name: BJ_IF_TSMCN28_PHY_SCH_V100
* Cell Name:    asic_io_p2
* View Name:    schematic
************************************************************************

.SUBCKT asic_io_p2 array_rwdl asic_out_en data_from_asic data_to_asic vdd
+ vdd_array vss vss_array
*.PININFO asic_out_en:I data_from_asic:I vdd:I vdd_array:I vss:I vss_array:I
*.PININFO data_to_asic:O array_rwdl:B
Xrddata array_rwdl asic_out_en_n data_to_asic vdd vdd_array vss vss_array /
+ asic_in_p2
Xi4 data_from_asic vdd vss net024 / BUFFD2BWP7T30P140
Xi12 array_rwdl vdd_array vss_array net011 / phy_latch_inv_hv_x1p5_v3
Xwrdata vdd_array vss_array net024 array_rwdl vdd vss asic_out_en_s
+ asic_out_en_n / levelshift_1p1en_P2
Xi17 asic_out_en vdd_array vss_array asic_out_en_s asic_out_en_n vdd vss /
+ Levelshift_1p1_small
Xi5 net011 vdd_array vss_array array_rwdl / phy_latch_inv_hv_x1_v3
.ENDS

************************************************************************
* Library Name: BJ_IF_TSMCN28_PHY_SCH_V100
* Cell Name:    level_shift
* View Name:    schematic
************************************************************************

.SUBCKT level_shift D DVDD DVSS VDD VSS en out pd_b pu_b
*.PININFO D:I en:I pd_b:I pu_b:I out:O DVDD:B DVSS:B VDD:B VSS:B
MPM1 D_n D DVDD DVDD pch_18ud12_mac l=90n w=1.6u m=1 nf=1
MPM2 D_ls D_n VDD VDD pch_18ud12_mac l=90n w=1.6u m=1 nf=1
Xi4 pd_b VDD VSS net046 / INVD2BWP7T30P140
MNM2 D_ls D_n net048 VSS nch_18ud12_mac l=90n w=1.6u m=1 nf=1
MNM3 D_n D DVSS DVSS nch_18ud12_mac l=90n w=1.6u m=1 nf=1
MNM1 net048 en VSS VSS nch_18ud12_mac l=90n w=1.6u m=1 nf=1
MPM0 D_ls pu_b VDD VDD pch_mac l=30n w=220.0n m=1 nf=1
Xi3 D_ls VDD VSS out / BUFFD4BWP7T30P140
CC4 D_ls VSS 3f $[CP]
CC0 out VSS 10f $[CP]
CC3 D_n DVSS 3f $[CP]
MNM0 D_ls net046 VSS VSS nch_mac l=30n w=200n m=1 nf=1
.ENDS

************************************************************************
* Library Name: BJ_IF_TSMCN28_PHY_SCH_V100
* Cell Name:    asic_in
* View Name:    schematic
************************************************************************

.SUBCKT asic_in A LS_en Y pd_n pu_n vdd vdd_array vss vss_array
*.PININFO A:I LS_en:I pd_n:I pu_n:I vdd:I vdd_array:I vss:I vss_array:I Y:O
Xlevel_shift A vdd_array vss_array vdd vss LS_en net7 pd_n pu_n / level_shift
Xi5<1> net7 vdd vss Y / BUFFD16BWP7T30P140
Xi5<0> net7 vdd vss Y / BUFFD16BWP7T30P140
.ENDS

************************************************************************
* Library Name: BJ_IF_TSMCN28_PHY_SCH_V100
* Cell Name:    ND2D2BWP7T30P140
* View Name:    schematic
************************************************************************

.SUBCKT ND2D2BWP7T30P140 A1 A2 VDD VSS ZN
*.PININFO A1:B A2:B VDD:B VSS:B ZN:B
MMM4 ZN A1 net10 VSS nch_mac l=30n w=200n m=1 nf=1
MMM4_2 ZN A1 net10 VSS nch_mac l=30n w=200n m=1 nf=1
MMM9 net10 A2 VSS VSS nch_mac l=30n w=200n m=1 nf=1
MMM9_2 net10 A2 VSS VSS nch_mac l=30n w=200n m=1 nf=1
MMM1 ZN A1 VDD VDD pch_mac l=30n w=210.0n m=1 nf=1
MMM1_2 ZN A1 VDD VDD pch_mac l=30n w=210.0n m=1 nf=1
MMM2 ZN A2 VDD VDD pch_mac l=30n w=210.0n m=1 nf=1
MMM2_2 ZN A2 VDD VDD pch_mac l=30n w=210.0n m=1 nf=1
.ENDS

************************************************************************
* Library Name: BJ_IF_TSMCN28_PHY_SCH_V100
* Cell Name:    INVD4BWP7T30P140
* View Name:    schematic
************************************************************************

.SUBCKT INVD4BWP7T30P140 I VDD VSS ZN
*.PININFO I:B VDD:B VSS:B ZN:B
MMM1 ZN I VSS VSS nch_mac l=30n w=200n m=1 nf=1
MMM1_2 ZN I VSS VSS nch_mac l=30n w=200n m=1 nf=1
MMM1_3 ZN I VSS VSS nch_mac l=30n w=200n m=1 nf=1
MMM1_4 ZN I VSS VSS nch_mac l=30n w=200n m=1 nf=1
MMM0 ZN I VDD VDD pch_mac l=30n w=220.0n m=1 nf=1
MMM0_2 ZN I VDD VDD pch_mac l=30n w=220.0n m=1 nf=1
MMM0_3 ZN I VDD VDD pch_mac l=30n w=220.0n m=1 nf=1
MMM0_4 ZN I VDD VDD pch_mac l=30n w=220.0n m=1 nf=1
.ENDS

************************************************************************
* Library Name: BJ_IF_TSMCN28_PHY_SCH_V100
* Cell Name:    NmCKGX2
* View Name:    schematic
************************************************************************

.SUBCKT NmCKGX2 CK CKEN EN vdd vss
*.PININFO CK:I EN:I CKEN:O vdd:B vss:B
Xi201 clk_ckg_n vdd vss clk_ckg / GINVD4BWP7T30P140
Xi203 q_ckg CK vdd vss net5 / ND2D2BWP7T30P140
Xi202 net5 vdd vss CKEN / INVD4BWP7T30P140
Xi197 q_ckg clk_ckg clk_ckg_n vdd vss net9 / phy_trinv
Xi196 EN clk_ckg_n clk_ckg vdd vss net9 / phy_trinv
Xi200 CK vdd vss clk_ckg_n / INVD2BWP7T30P140
Xi199 net9 vdd vss q_ckg / INVD2BWP7T30P140
.ENDS

************************************************************************
* Library Name: BJ_IF_TSMCN28_PHY_SCH_V100
* Cell Name:    hb_macro_dly_dec
* View Name:    schematic
************************************************************************

.SUBCKT hb_macro_dly_dec cfg_dly_sel[1] cfg_dly_sel[0] cfg_sel_0 cfg_sel_0_n
+ cfg_sel_1 cfg_sel_1_n cfg_sel_2 cfg_sel_2_n cfg_sel_3 cfg_sel_3_n vdd vss
*.PININFO cfg_dly_sel[1]:I cfg_dly_sel[0]:I vdd:I vss:I cfg_sel_0:O
*.PININFO cfg_sel_0_n:O cfg_sel_1:O cfg_sel_1_n:O cfg_sel_2:O cfg_sel_2_n:O
*.PININFO cfg_sel_3:O cfg_sel_3_n:O
Xi21 cfg_dly_sel_n[0] cfg_dly_sel[1] vdd vss cfg_sel_2_n / ND2D2BWP7T30P140
Xi18 cfg_dly_sel_n[0] cfg_dly_sel_n[1] vdd vss cfg_sel_0_n / ND2D2BWP7T30P140
Xi19 cfg_dly_sel[0] cfg_dly_sel_n[1] vdd vss cfg_sel_1_n / ND2D2BWP7T30P140
Xi20 cfg_dly_sel[0] cfg_dly_sel[1] vdd vss cfg_sel_3_n / ND2D2BWP7T30P140
Xi10 cfg_sel_0_n vdd vss cfg_sel_0 / INVD2BWP7T30P140
Xi12 cfg_sel_2_n vdd vss cfg_sel_2 / INVD2BWP7T30P140
Xi11 cfg_sel_1_n vdd vss cfg_sel_1 / INVD2BWP7T30P140
Xi9<1> cfg_dly_sel[1] vdd vss cfg_dly_sel_n[1] / INVD2BWP7T30P140
Xi9<0> cfg_dly_sel[0] vdd vss cfg_dly_sel_n[0] / INVD2BWP7T30P140
Xi13 cfg_sel_3_n vdd vss cfg_sel_3 / INVD2BWP7T30P140
.ENDS

************************************************************************
* Library Name: BJ_IF_TSMCN28_PHY_SCH_V100
* Cell Name:    TIELBWP7T30P140
* View Name:    schematic
************************************************************************

.SUBCKT TIELBWP7T30P140 VDD VSS ZN
*.PININFO VDD:B VSS:B ZN:B
MMM8 ZN net10 VSS VSS nch_mac l=30n w=200n m=1 nf=1
MMM5 net10 net10 VDD VDD pch_mac l=30n w=220.0n m=1 nf=1
.ENDS

************************************************************************
* Library Name: BJ_IF_TSMCN28_PHY_SCH_V100
* Cell Name:    BUFFD12BWP7T30P140
* View Name:    schematic
************************************************************************

.SUBCKT BUFFD12BWP7T30P140 I VDD VSS Z
*.PININFO I:B VDD:B VSS:B Z:B
MMM0 Z net55 VSS VSS nch_mac l=30n w=200n m=1 nf=1
MMM0_2 Z net55 VSS VSS nch_mac l=30n w=200n m=1 nf=1
MMM0_3 Z net55 VSS VSS nch_mac l=30n w=200n m=1 nf=1
MMM0_4 Z net55 VSS VSS nch_mac l=30n w=200n m=1 nf=1
MMM0_5 Z net55 VSS VSS nch_mac l=30n w=200n m=1 nf=1
MMM0_6 Z net55 VSS VSS nch_mac l=30n w=200n m=1 nf=1
MMM0_7 Z net55 VSS VSS nch_mac l=30n w=200n m=1 nf=1
MMM0_8 Z net55 VSS VSS nch_mac l=30n w=200n m=1 nf=1
MMM0_9 Z net55 VSS VSS nch_mac l=30n w=200n m=1 nf=1
MMM0_10 Z net55 VSS VSS nch_mac l=30n w=200n m=1 nf=1
MMM0_11 Z net55 VSS VSS nch_mac l=30n w=200n m=1 nf=1
MMM0_12 Z net55 VSS VSS nch_mac l=30n w=200n m=1 nf=1
MMM19 net55 I VSS VSS nch_mac l=30n w=200n m=1 nf=1
MMM19_2 net55 I VSS VSS nch_mac l=30n w=200n m=1 nf=1
MMM19_3 net55 I VSS VSS nch_mac l=30n w=200n m=1 nf=1
MMM19_4 net55 I VSS VSS nch_mac l=30n w=200n m=1 nf=1
MMM21 net55 I VDD VDD pch_mac l=30n w=220.0n m=1 nf=1
MMM21_2 net55 I VDD VDD pch_mac l=30n w=220.0n m=1 nf=1
MMM21_3 net55 I VDD VDD pch_mac l=30n w=220.0n m=1 nf=1
MMM21_4 net55 I VDD VDD pch_mac l=30n w=220.0n m=1 nf=1
MMM20 Z net55 VDD VDD pch_mac l=30n w=220.0n m=1 nf=1
MMM20_2 Z net55 VDD VDD pch_mac l=30n w=220.0n m=1 nf=1
MMM20_3 Z net55 VDD VDD pch_mac l=30n w=220.0n m=1 nf=1
MMM20_4 Z net55 VDD VDD pch_mac l=30n w=220.0n m=1 nf=1
MMM20_5 Z net55 VDD VDD pch_mac l=30n w=220.0n m=1 nf=1
MMM20_6 Z net55 VDD VDD pch_mac l=30n w=220.0n m=1 nf=1
MMM20_7 Z net55 VDD VDD pch_mac l=30n w=220.0n m=1 nf=1
MMM20_8 Z net55 VDD VDD pch_mac l=30n w=220.0n m=1 nf=1
MMM20_9 Z net55 VDD VDD pch_mac l=30n w=220.0n m=1 nf=1
MMM20_10 Z net55 VDD VDD pch_mac l=30n w=220.0n m=1 nf=1
MMM20_11 Z net55 VDD VDD pch_mac l=30n w=220.0n m=1 nf=1
MMM20_12 Z net55 VDD VDD pch_mac l=30n w=220.0n m=1 nf=1
.ENDS

************************************************************************
* Library Name: BJ_IF_TSMCN28_PHY_SCH_V100
* Cell Name:    Levelshift_1p1buf_large
* View Name:    schematic
************************************************************************

.SUBCKT Levelshift_1p1buf_large DVDD DVSS Din Dout VDD VSS
*.PININFO Din:I Dout:O DVDD:B DVSS:B VDD:B VSS:B
XI3 Din DVDD DVSS D_ls VDD VSS / Levelshift_1p1
MM1 D_ls_b D_ls DVDD DVDD pch_18ud12_mac l=90n w=1.6u m=1 nf=1
MM2 Dout D_ls_b DVDD DVDD pch_18ud12_mac l=90n w=1.6u m=10 nf=1
MM0 D_ls_b D_ls DVSS DVSS nch_18ud12_mac l=90n w=1.6u m=1 nf=1
MM3 Dout D_ls_b DVSS DVSS nch_18ud12_mac l=90n w=1.6u m=8 nf=1
.ENDS

************************************************************************
* Library Name: BJ_IF_TSMCN28_PHY_SCH_V100
* Cell Name:    hb_diode
* View Name:    schematic
************************************************************************

.SUBCKT hb_diode inp vdd vss
*.PININFO inp:I vdd:B vss:B
MNM0 inp vss vss vss nch_18ud12_mac l=90n w=400n m=1 nf=1
MPM0 inp vdd vdd vdd pch_18ud12_mac l=90n w=400n m=1 nf=1
.ENDS

************************************************************************
* Library Name: BJ_IF_TSMCN28_PHY_SCH_V100
* Cell Name:    DFCNQD1BWP7T30P140
* View Name:    schematic
************************************************************************

.SUBCKT DFCNQD1BWP7T30P140 CDN CP D Q VDD VSS
*.PININFO CDN:B CP:B D:B Q:B VDD:B VSS:B
MMM7 net0125 mq VSS VSS nch_mac l=3e-08 w=100n m=1 nf=1
MMM6 net0129 CDN net0125 VSS nch_mac l=3e-08 w=100n m=1 nf=1
MMM65 mq_x clkbb net0129 VSS nch_mac l=3e-08 w=100n m=1 nf=1
MMM46 mq_x clkb net212 VSS nch_mac l=30n w=140.0n m=1 nf=1
MMM47 net212 D VSS VSS nch_mac l=30n w=140.0n m=1 nf=1
MMM71 Q qf_x VSS VSS nch_mac l=30n w=200n m=1 nf=1
MMM53 clkb CP VSS VSS nch_mac l=30n w=200n m=1 nf=1
MMM4 qf clkb net0152 VSS nch_mac l=3e-08 w=100n m=1 nf=1
MMM12 net0152 qf_x VSS VSS nch_mac l=3e-08 w=100n m=1 nf=1
MMM76 qf_x qf net208 VSS nch_mac l=30n w=200n m=1 nf=1
MMM75 net208 CDN VSS VSS nch_mac l=30n w=200n m=1 nf=1
MMM55 clkbb clkb VSS VSS nch_mac l=30n w=200n m=1 nf=1
MMSLTn1 qf clkbb mq VSS nch_mac l=30n w=140.0n m=1 nf=1
MMM1 mq mq_x VSS VSS nch_mac l=30n w=140.0n m=1 nf=1
MMM44 net103 D VDD VDD pch_mac l=30n w=200n m=1 nf=1
MMM45 mq_x clkbb net103 VDD pch_mac l=30n w=200n m=1 nf=1
MMM11 qf clkbb net093 VDD pch_mac l=3e-08 w=100n m=1 nf=1
MMM2 net093 qf_x VDD VDD pch_mac l=30n w=110.0n m=1 nf=1
MMM72 Q qf_x VDD VDD pch_mac l=30n w=220.0n m=1 nf=1
MMM54 clkb CP VDD VDD pch_mac l=30n w=220.0n m=1 nf=1
MMM77 qf_x qf VDD VDD pch_mac l=30n w=220.0n m=1 nf=1
MMM56 clkbb clkb VDD VDD pch_mac l=30n w=220.0n m=1 nf=1
MMM78 qf_x CDN VDD VDD pch_mac l=30n w=220.0n m=1 nf=1
MMM10 net0183 CDN VDD VDD pch_mac l=30n w=115.00n m=1 nf=1
MMM8 net0183 mq VDD VDD pch_mac l=30n w=115.00n m=1 nf=1
MMM9 mq_x clkb net0183 VDD pch_mac l=30n w=115.00n m=1 nf=1
MMM0 mq mq_x VDD VDD pch_mac l=30n w=200n m=1 nf=1
MMSLTp1 qf clkb mq VDD pch_mac l=30n w=200n m=1 nf=1
.ENDS

************************************************************************
* Library Name: BJ_IF_TSMCN28_PHY_SCH_V100
* Cell Name:    dly_unit_full
* View Name:    schematic
************************************************************************

.SUBCKT dly_unit_full A Y vdd vss
*.PININFO A:I vdd:I vss:I Y:O
Xi9 A vdd vss net2 / BUF_DLY
Xi26 net4 vdd vss net3 / BUF_DLY
Xi27 net3 vdd vss Y / BUF_DLY
Xi25 net2 vdd vss net4 / BUF_DLY
.ENDS

************************************************************************
* Library Name: BJ_IF_TSMCN28_PHY_SCH_V100
* Cell Name:    hb_macro_dly_full
* View Name:    schematic
************************************************************************

.SUBCKT hb_macro_dly_full A Y cfg_sel_0 cfg_sel_0_n cfg_sel_1 cfg_sel_1_n
+ cfg_sel_2 cfg_sel_2_n cfg_sel_3 cfg_sel_3_n vdd vss
*.PININFO A:I cfg_sel_0:I cfg_sel_0_n:I cfg_sel_1:I cfg_sel_1_n:I cfg_sel_2:I
*.PININFO cfg_sel_2_n:I cfg_sel_3:I cfg_sel_3_n:I vdd:I vss:I Y:O
Xi20 to_array_n vdd vss Y / INVD2BWP7T30P140
Xu_dly_32 dly2 dly3 vdd vss / dly_unit_full
Xu_dly_31 dly1 dly2 vdd vss / dly_unit_full
Xu_dly_30 A dly1 vdd vss / dly_unit_full
Xsel_1 dly1 cfg_sel_1 cfg_sel_1_n vdd vss to_array_n / phy_trinv
Xsel_0 A cfg_sel_0 cfg_sel_0_n vdd vss to_array_n / phy_trinv
Xsel_3 dly3 cfg_sel_3 cfg_sel_3_n vdd vss to_array_n / phy_trinv
Xsel_2 dly2 cfg_sel_2 cfg_sel_2_n vdd vss to_array_n / phy_trinv
.ENDS

************************************************************************
* Library Name: BJ_IF_TSMCN28_PHY_SCH_V100
* Cell Name:    hb_macro_bnk_230m_4s_sample
* View Name:    schematic
************************************************************************

.SUBCKT hb_macro_bnk_230m_4s_sample bnksel_n_array_0 bnksel_n_array_1
+ bnksel_n_asic_0 bnksel_n_asic_1 cfg_dly_bnksel_n_0[1] cfg_dly_bnksel_n_0[0]
+ cfg_dly_bnksel_n_1[1] cfg_dly_bnksel_n_1[0] cfg_dly_gcadd[1]
+ cfg_dly_gcadd[0] cfg_dly_gcas_rd_0[1] cfg_dly_gcas_rd_0[0]
+ cfg_dly_gcas_rd_1[1] cfg_dly_gcas_rd_1[0] cfg_dly_gcas_wr_0[1]
+ cfg_dly_gcas_wr_0[0] cfg_dly_gcas_wr_1[1] cfg_dly_gcas_wr_1[0] clk_in_asic
+ gcadd_array[7] gcadd_array[6] gcadd_array[5] gcadd_array[4] gcadd_array[3]
+ gcadd_array[2] gcadd_array[1] gcadd_array[0] gcadd_asic[7] gcadd_asic[6]
+ gcadd_asic[5] gcadd_asic[4] gcadd_asic[3] gcadd_asic[2] gcadd_asic[1]
+ gcadd_asic[0] gcas_rd_array_0 gcas_rd_array_1 gcas_rd_en_asic_0
+ gcas_rd_en_asic_1 gcas_wr_array_0 gcas_wr_array_1 gcas_wr_en_asic_0
+ gcas_wr_en_asic_1 gradd_array[12] gradd_array[11] gradd_array[10]
+ gradd_array[9] gradd_array[8] gradd_array[7] gradd_array[6] gradd_array[5]
+ gradd_array[4] gradd_array[3] gradd_array[2] gradd_array[1] gradd_array[0]
+ gradd_asic[12] gradd_asic[11] gradd_asic[10] gradd_asic[9] gradd_asic[8]
+ gradd_asic[7] gradd_asic[6] gradd_asic[5] gradd_asic[4] gradd_asic[3]
+ gradd_asic[2] gradd_asic[1] gradd_asic[0] ls_en_asic rdata_asic[271]
+ rdata_asic[270] rdata_asic[269] rdata_asic[268] rdata_asic[267]
+ rdata_asic[266] rdata_asic[265] rdata_asic[264] rdata_asic[263]
+ rdata_asic[262] rdata_asic[261] rdata_asic[260] rdata_asic[259]
+ rdata_asic[258] rdata_asic[257] rdata_asic[256] rdata_asic[255]
+ rdata_asic[254] rdata_asic[253] rdata_asic[252] rdata_asic[251]
+ rdata_asic[250] rdata_asic[249] rdata_asic[248] rdata_asic[247]
+ rdata_asic[246] rdata_asic[245] rdata_asic[244] rdata_asic[243]
+ rdata_asic[242] rdata_asic[241] rdata_asic[240] rdata_asic[239]
+ rdata_asic[238] rdata_asic[237] rdata_asic[236] rdata_asic[235]
+ rdata_asic[234] rdata_asic[233] rdata_asic[232] rdata_asic[231]
+ rdata_asic[230] rdata_asic[229] rdata_asic[228] rdata_asic[227]
+ rdata_asic[226] rdata_asic[225] rdata_asic[224] rdata_asic[223]
+ rdata_asic[222] rdata_asic[221] rdata_asic[220] rdata_asic[219]
+ rdata_asic[218] rdata_asic[217] rdata_asic[216] rdata_asic[215]
+ rdata_asic[214] rdata_asic[213] rdata_asic[212] rdata_asic[211]
+ rdata_asic[210] rdata_asic[209] rdata_asic[208] rdata_asic[207]
+ rdata_asic[206] rdata_asic[205] rdata_asic[204] rdata_asic[203]
+ rdata_asic[202] rdata_asic[201] rdata_asic[200] rdata_asic[199]
+ rdata_asic[198] rdata_asic[197] rdata_asic[196] rdata_asic[195]
+ rdata_asic[194] rdata_asic[193] rdata_asic[192] rdata_asic[191]
+ rdata_asic[190] rdata_asic[189] rdata_asic[188] rdata_asic[187]
+ rdata_asic[186] rdata_asic[185] rdata_asic[184] rdata_asic[183]
+ rdata_asic[182] rdata_asic[181] rdata_asic[180] rdata_asic[179]
+ rdata_asic[178] rdata_asic[177] rdata_asic[176] rdata_asic[175]
+ rdata_asic[174] rdata_asic[173] rdata_asic[172] rdata_asic[171]
+ rdata_asic[170] rdata_asic[169] rdata_asic[168] rdata_asic[167]
+ rdata_asic[166] rdata_asic[165] rdata_asic[164] rdata_asic[163]
+ rdata_asic[162] rdata_asic[161] rdata_asic[160] rdata_asic[159]
+ rdata_asic[158] rdata_asic[157] rdata_asic[156] rdata_asic[155]
+ rdata_asic[154] rdata_asic[153] rdata_asic[152] rdata_asic[151]
+ rdata_asic[150] rdata_asic[149] rdata_asic[148] rdata_asic[147]
+ rdata_asic[146] rdata_asic[145] rdata_asic[144] rdata_asic[143]
+ rdata_asic[142] rdata_asic[141] rdata_asic[140] rdata_asic[139]
+ rdata_asic[138] rdata_asic[137] rdata_asic[136] rdata_asic[135]
+ rdata_asic[134] rdata_asic[133] rdata_asic[132] rdata_asic[131]
+ rdata_asic[130] rdata_asic[129] rdata_asic[128] rdata_asic[127]
+ rdata_asic[126] rdata_asic[125] rdata_asic[124] rdata_asic[123]
+ rdata_asic[122] rdata_asic[121] rdata_asic[120] rdata_asic[119]
+ rdata_asic[118] rdata_asic[117] rdata_asic[116] rdata_asic[115]
+ rdata_asic[114] rdata_asic[113] rdata_asic[112] rdata_asic[111]
+ rdata_asic[110] rdata_asic[109] rdata_asic[108] rdata_asic[107]
+ rdata_asic[106] rdata_asic[105] rdata_asic[104] rdata_asic[103]
+ rdata_asic[102] rdata_asic[101] rdata_asic[100] rdata_asic[99]
+ rdata_asic[98] rdata_asic[97] rdata_asic[96] rdata_asic[95] rdata_asic[94]
+ rdata_asic[93] rdata_asic[92] rdata_asic[91] rdata_asic[90] rdata_asic[89]
+ rdata_asic[88] rdata_asic[87] rdata_asic[86] rdata_asic[85] rdata_asic[84]
+ rdata_asic[83] rdata_asic[82] rdata_asic[81] rdata_asic[80] rdata_asic[79]
+ rdata_asic[78] rdata_asic[77] rdata_asic[76] rdata_asic[75] rdata_asic[74]
+ rdata_asic[73] rdata_asic[72] rdata_asic[71] rdata_asic[70] rdata_asic[69]
+ rdata_asic[68] rdata_asic[67] rdata_asic[66] rdata_asic[65] rdata_asic[64]
+ rdata_asic[63] rdata_asic[62] rdata_asic[61] rdata_asic[60] rdata_asic[59]
+ rdata_asic[58] rdata_asic[57] rdata_asic[56] rdata_asic[55] rdata_asic[54]
+ rdata_asic[53] rdata_asic[52] rdata_asic[51] rdata_asic[50] rdata_asic[49]
+ rdata_asic[48] rdata_asic[47] rdata_asic[46] rdata_asic[45] rdata_asic[44]
+ rdata_asic[43] rdata_asic[42] rdata_asic[41] rdata_asic[40] rdata_asic[39]
+ rdata_asic[38] rdata_asic[37] rdata_asic[36] rdata_asic[35] rdata_asic[34]
+ rdata_asic[33] rdata_asic[32] rdata_asic[31] rdata_asic[30] rdata_asic[29]
+ rdata_asic[28] rdata_asic[27] rdata_asic[26] rdata_asic[25] rdata_asic[24]
+ rdata_asic[23] rdata_asic[22] rdata_asic[21] rdata_asic[20] rdata_asic[19]
+ rdata_asic[18] rdata_asic[17] rdata_asic[16] rdata_asic[15] rdata_asic[14]
+ rdata_asic[13] rdata_asic[12] rdata_asic[11] rdata_asic[10] rdata_asic[9]
+ rdata_asic[8] rdata_asic[7] rdata_asic[6] rdata_asic[5] rdata_asic[4]
+ rdata_asic[3] rdata_asic[2] rdata_asic[1] rdata_asic[0] rdrdy_n_array_0
+ rdrdy_n_array_1 rdrdy_n_asic reset_n_array reset_n_asic rwdl_array[271]
+ rwdl_array[270] rwdl_array[269] rwdl_array[268] rwdl_array[267]
+ rwdl_array[266] rwdl_array[265] rwdl_array[264] rwdl_array[263]
+ rwdl_array[262] rwdl_array[261] rwdl_array[260] rwdl_array[259]
+ rwdl_array[258] rwdl_array[257] rwdl_array[256] rwdl_array[255]
+ rwdl_array[254] rwdl_array[253] rwdl_array[252] rwdl_array[251]
+ rwdl_array[250] rwdl_array[249] rwdl_array[248] rwdl_array[247]
+ rwdl_array[246] rwdl_array[245] rwdl_array[244] rwdl_array[243]
+ rwdl_array[242] rwdl_array[241] rwdl_array[240] rwdl_array[239]
+ rwdl_array[238] rwdl_array[237] rwdl_array[236] rwdl_array[235]
+ rwdl_array[234] rwdl_array[233] rwdl_array[232] rwdl_array[231]
+ rwdl_array[230] rwdl_array[229] rwdl_array[228] rwdl_array[227]
+ rwdl_array[226] rwdl_array[225] rwdl_array[224] rwdl_array[223]
+ rwdl_array[222] rwdl_array[221] rwdl_array[220] rwdl_array[219]
+ rwdl_array[218] rwdl_array[217] rwdl_array[216] rwdl_array[215]
+ rwdl_array[214] rwdl_array[213] rwdl_array[212] rwdl_array[211]
+ rwdl_array[210] rwdl_array[209] rwdl_array[208] rwdl_array[207]
+ rwdl_array[206] rwdl_array[205] rwdl_array[204] rwdl_array[203]
+ rwdl_array[202] rwdl_array[201] rwdl_array[200] rwdl_array[199]
+ rwdl_array[198] rwdl_array[197] rwdl_array[196] rwdl_array[195]
+ rwdl_array[194] rwdl_array[193] rwdl_array[192] rwdl_array[191]
+ rwdl_array[190] rwdl_array[189] rwdl_array[188] rwdl_array[187]
+ rwdl_array[186] rwdl_array[185] rwdl_array[184] rwdl_array[183]
+ rwdl_array[182] rwdl_array[181] rwdl_array[180] rwdl_array[179]
+ rwdl_array[178] rwdl_array[177] rwdl_array[176] rwdl_array[175]
+ rwdl_array[174] rwdl_array[173] rwdl_array[172] rwdl_array[171]
+ rwdl_array[170] rwdl_array[169] rwdl_array[168] rwdl_array[167]
+ rwdl_array[166] rwdl_array[165] rwdl_array[164] rwdl_array[163]
+ rwdl_array[162] rwdl_array[161] rwdl_array[160] rwdl_array[159]
+ rwdl_array[158] rwdl_array[157] rwdl_array[156] rwdl_array[155]
+ rwdl_array[154] rwdl_array[153] rwdl_array[152] rwdl_array[151]
+ rwdl_array[150] rwdl_array[149] rwdl_array[148] rwdl_array[147]
+ rwdl_array[146] rwdl_array[145] rwdl_array[144] rwdl_array[143]
+ rwdl_array[142] rwdl_array[141] rwdl_array[140] rwdl_array[139]
+ rwdl_array[138] rwdl_array[137] rwdl_array[136] rwdl_array[135]
+ rwdl_array[134] rwdl_array[133] rwdl_array[132] rwdl_array[131]
+ rwdl_array[130] rwdl_array[129] rwdl_array[128] rwdl_array[127]
+ rwdl_array[126] rwdl_array[125] rwdl_array[124] rwdl_array[123]
+ rwdl_array[122] rwdl_array[121] rwdl_array[120] rwdl_array[119]
+ rwdl_array[118] rwdl_array[117] rwdl_array[116] rwdl_array[115]
+ rwdl_array[114] rwdl_array[113] rwdl_array[112] rwdl_array[111]
+ rwdl_array[110] rwdl_array[109] rwdl_array[108] rwdl_array[107]
+ rwdl_array[106] rwdl_array[105] rwdl_array[104] rwdl_array[103]
+ rwdl_array[102] rwdl_array[101] rwdl_array[100] rwdl_array[99]
+ rwdl_array[98] rwdl_array[97] rwdl_array[96] rwdl_array[95] rwdl_array[94]
+ rwdl_array[93] rwdl_array[92] rwdl_array[91] rwdl_array[90] rwdl_array[89]
+ rwdl_array[88] rwdl_array[87] rwdl_array[86] rwdl_array[85] rwdl_array[84]
+ rwdl_array[83] rwdl_array[82] rwdl_array[81] rwdl_array[80] rwdl_array[79]
+ rwdl_array[78] rwdl_array[77] rwdl_array[76] rwdl_array[75] rwdl_array[74]
+ rwdl_array[73] rwdl_array[72] rwdl_array[71] rwdl_array[70] rwdl_array[69]
+ rwdl_array[68] rwdl_array[67] rwdl_array[66] rwdl_array[65] rwdl_array[64]
+ rwdl_array[63] rwdl_array[62] rwdl_array[61] rwdl_array[60] rwdl_array[59]
+ rwdl_array[58] rwdl_array[57] rwdl_array[56] rwdl_array[55] rwdl_array[54]
+ rwdl_array[53] rwdl_array[52] rwdl_array[51] rwdl_array[50] rwdl_array[49]
+ rwdl_array[48] rwdl_array[47] rwdl_array[46] rwdl_array[45] rwdl_array[44]
+ rwdl_array[43] rwdl_array[42] rwdl_array[41] rwdl_array[40] rwdl_array[39]
+ rwdl_array[38] rwdl_array[37] rwdl_array[36] rwdl_array[35] rwdl_array[34]
+ rwdl_array[33] rwdl_array[32] rwdl_array[31] rwdl_array[30] rwdl_array[29]
+ rwdl_array[28] rwdl_array[27] rwdl_array[26] rwdl_array[25] rwdl_array[24]
+ rwdl_array[23] rwdl_array[22] rwdl_array[21] rwdl_array[20] rwdl_array[19]
+ rwdl_array[18] rwdl_array[17] rwdl_array[16] rwdl_array[15] rwdl_array[14]
+ rwdl_array[13] rwdl_array[12] rwdl_array[11] rwdl_array[10] rwdl_array[9]
+ rwdl_array[8] rwdl_array[7] rwdl_array[6] rwdl_array[5] rwdl_array[4]
+ rwdl_array[3] rwdl_array[2] rwdl_array[1] rwdl_array[0] vdd vdd_array vss
+ wdata_asic[271] wdata_asic[270] wdata_asic[269] wdata_asic[268]
+ wdata_asic[267] wdata_asic[266] wdata_asic[265] wdata_asic[264]
+ wdata_asic[263] wdata_asic[262] wdata_asic[261] wdata_asic[260]
+ wdata_asic[259] wdata_asic[258] wdata_asic[257] wdata_asic[256]
+ wdata_asic[255] wdata_asic[254] wdata_asic[253] wdata_asic[252]
+ wdata_asic[251] wdata_asic[250] wdata_asic[249] wdata_asic[248]
+ wdata_asic[247] wdata_asic[246] wdata_asic[245] wdata_asic[244]
+ wdata_asic[243] wdata_asic[242] wdata_asic[241] wdata_asic[240]
+ wdata_asic[239] wdata_asic[238] wdata_asic[237] wdata_asic[236]
+ wdata_asic[235] wdata_asic[234] wdata_asic[233] wdata_asic[232]
+ wdata_asic[231] wdata_asic[230] wdata_asic[229] wdata_asic[228]
+ wdata_asic[227] wdata_asic[226] wdata_asic[225] wdata_asic[224]
+ wdata_asic[223] wdata_asic[222] wdata_asic[221] wdata_asic[220]
+ wdata_asic[219] wdata_asic[218] wdata_asic[217] wdata_asic[216]
+ wdata_asic[215] wdata_asic[214] wdata_asic[213] wdata_asic[212]
+ wdata_asic[211] wdata_asic[210] wdata_asic[209] wdata_asic[208]
+ wdata_asic[207] wdata_asic[206] wdata_asic[205] wdata_asic[204]
+ wdata_asic[203] wdata_asic[202] wdata_asic[201] wdata_asic[200]
+ wdata_asic[199] wdata_asic[198] wdata_asic[197] wdata_asic[196]
+ wdata_asic[195] wdata_asic[194] wdata_asic[193] wdata_asic[192]
+ wdata_asic[191] wdata_asic[190] wdata_asic[189] wdata_asic[188]
+ wdata_asic[187] wdata_asic[186] wdata_asic[185] wdata_asic[184]
+ wdata_asic[183] wdata_asic[182] wdata_asic[181] wdata_asic[180]
+ wdata_asic[179] wdata_asic[178] wdata_asic[177] wdata_asic[176]
+ wdata_asic[175] wdata_asic[174] wdata_asic[173] wdata_asic[172]
+ wdata_asic[171] wdata_asic[170] wdata_asic[169] wdata_asic[168]
+ wdata_asic[167] wdata_asic[166] wdata_asic[165] wdata_asic[164]
+ wdata_asic[163] wdata_asic[162] wdata_asic[161] wdata_asic[160]
+ wdata_asic[159] wdata_asic[158] wdata_asic[157] wdata_asic[156]
+ wdata_asic[155] wdata_asic[154] wdata_asic[153] wdata_asic[152]
+ wdata_asic[151] wdata_asic[150] wdata_asic[149] wdata_asic[148]
+ wdata_asic[147] wdata_asic[146] wdata_asic[145] wdata_asic[144]
+ wdata_asic[143] wdata_asic[142] wdata_asic[141] wdata_asic[140]
+ wdata_asic[139] wdata_asic[138] wdata_asic[137] wdata_asic[136]
+ wdata_asic[135] wdata_asic[134] wdata_asic[133] wdata_asic[132]
+ wdata_asic[131] wdata_asic[130] wdata_asic[129] wdata_asic[128]
+ wdata_asic[127] wdata_asic[126] wdata_asic[125] wdata_asic[124]
+ wdata_asic[123] wdata_asic[122] wdata_asic[121] wdata_asic[120]
+ wdata_asic[119] wdata_asic[118] wdata_asic[117] wdata_asic[116]
+ wdata_asic[115] wdata_asic[114] wdata_asic[113] wdata_asic[112]
+ wdata_asic[111] wdata_asic[110] wdata_asic[109] wdata_asic[108]
+ wdata_asic[107] wdata_asic[106] wdata_asic[105] wdata_asic[104]
+ wdata_asic[103] wdata_asic[102] wdata_asic[101] wdata_asic[100]
+ wdata_asic[99] wdata_asic[98] wdata_asic[97] wdata_asic[96] wdata_asic[95]
+ wdata_asic[94] wdata_asic[93] wdata_asic[92] wdata_asic[91] wdata_asic[90]
+ wdata_asic[89] wdata_asic[88] wdata_asic[87] wdata_asic[86] wdata_asic[85]
+ wdata_asic[84] wdata_asic[83] wdata_asic[82] wdata_asic[81] wdata_asic[80]
+ wdata_asic[79] wdata_asic[78] wdata_asic[77] wdata_asic[76] wdata_asic[75]
+ wdata_asic[74] wdata_asic[73] wdata_asic[72] wdata_asic[71] wdata_asic[70]
+ wdata_asic[69] wdata_asic[68] wdata_asic[67] wdata_asic[66] wdata_asic[65]
+ wdata_asic[64] wdata_asic[63] wdata_asic[62] wdata_asic[61] wdata_asic[60]
+ wdata_asic[59] wdata_asic[58] wdata_asic[57] wdata_asic[56] wdata_asic[55]
+ wdata_asic[54] wdata_asic[53] wdata_asic[52] wdata_asic[51] wdata_asic[50]
+ wdata_asic[49] wdata_asic[48] wdata_asic[47] wdata_asic[46] wdata_asic[45]
+ wdata_asic[44] wdata_asic[43] wdata_asic[42] wdata_asic[41] wdata_asic[40]
+ wdata_asic[39] wdata_asic[38] wdata_asic[37] wdata_asic[36] wdata_asic[35]
+ wdata_asic[34] wdata_asic[33] wdata_asic[32] wdata_asic[31] wdata_asic[30]
+ wdata_asic[29] wdata_asic[28] wdata_asic[27] wdata_asic[26] wdata_asic[25]
+ wdata_asic[24] wdata_asic[23] wdata_asic[22] wdata_asic[21] wdata_asic[20]
+ wdata_asic[19] wdata_asic[18] wdata_asic[17] wdata_asic[16] wdata_asic[15]
+ wdata_asic[14] wdata_asic[13] wdata_asic[12] wdata_asic[11] wdata_asic[10]
+ wdata_asic[9] wdata_asic[8] wdata_asic[7] wdata_asic[6] wdata_asic[5]
+ wdata_asic[4] wdata_asic[3] wdata_asic[2] wdata_asic[1] wdata_asic[0]
+ wdata_oe_asic
*.PININFO bnksel_n_asic_0:I bnksel_n_asic_1:I cfg_dly_bnksel_n_0[1]:I
*.PININFO cfg_dly_bnksel_n_0[0]:I cfg_dly_bnksel_n_1[1]:I
*.PININFO cfg_dly_bnksel_n_1[0]:I cfg_dly_gcadd[1]:I cfg_dly_gcadd[0]:I
*.PININFO cfg_dly_gcas_rd_0[1]:I cfg_dly_gcas_rd_0[0]:I cfg_dly_gcas_rd_1[1]:I
*.PININFO cfg_dly_gcas_rd_1[0]:I cfg_dly_gcas_wr_0[1]:I cfg_dly_gcas_wr_0[0]:I
*.PININFO cfg_dly_gcas_wr_1[1]:I cfg_dly_gcas_wr_1[0]:I clk_in_asic:I
*.PININFO gcadd_asic[7]:I gcadd_asic[6]:I gcadd_asic[5]:I gcadd_asic[4]:I
*.PININFO gcadd_asic[3]:I gcadd_asic[2]:I gcadd_asic[1]:I gcadd_asic[0]:I
*.PININFO gcas_rd_en_asic_0:I gcas_rd_en_asic_1:I gcas_wr_en_asic_0:I
*.PININFO gcas_wr_en_asic_1:I gradd_asic[12]:I gradd_asic[11]:I
*.PININFO gradd_asic[10]:I gradd_asic[9]:I gradd_asic[8]:I gradd_asic[7]:I
*.PININFO gradd_asic[6]:I gradd_asic[5]:I gradd_asic[4]:I gradd_asic[3]:I
*.PININFO gradd_asic[2]:I gradd_asic[1]:I gradd_asic[0]:I ls_en_asic:I
*.PININFO rdrdy_n_array_0:I rdrdy_n_array_1:I reset_n_asic:I wdata_asic[271]:I
*.PININFO wdata_asic[270]:I wdata_asic[269]:I wdata_asic[268]:I
*.PININFO wdata_asic[267]:I wdata_asic[266]:I wdata_asic[265]:I
*.PININFO wdata_asic[264]:I wdata_asic[263]:I wdata_asic[262]:I
*.PININFO wdata_asic[261]:I wdata_asic[260]:I wdata_asic[259]:I
*.PININFO wdata_asic[258]:I wdata_asic[257]:I wdata_asic[256]:I
*.PININFO wdata_asic[255]:I wdata_asic[254]:I wdata_asic[253]:I
*.PININFO wdata_asic[252]:I wdata_asic[251]:I wdata_asic[250]:I
*.PININFO wdata_asic[249]:I wdata_asic[248]:I wdata_asic[247]:I
*.PININFO wdata_asic[246]:I wdata_asic[245]:I wdata_asic[244]:I
*.PININFO wdata_asic[243]:I wdata_asic[242]:I wdata_asic[241]:I
*.PININFO wdata_asic[240]:I wdata_asic[239]:I wdata_asic[238]:I
*.PININFO wdata_asic[237]:I wdata_asic[236]:I wdata_asic[235]:I
*.PININFO wdata_asic[234]:I wdata_asic[233]:I wdata_asic[232]:I
*.PININFO wdata_asic[231]:I wdata_asic[230]:I wdata_asic[229]:I
*.PININFO wdata_asic[228]:I wdata_asic[227]:I wdata_asic[226]:I
*.PININFO wdata_asic[225]:I wdata_asic[224]:I wdata_asic[223]:I
*.PININFO wdata_asic[222]:I wdata_asic[221]:I wdata_asic[220]:I
*.PININFO wdata_asic[219]:I wdata_asic[218]:I wdata_asic[217]:I
*.PININFO wdata_asic[216]:I wdata_asic[215]:I wdata_asic[214]:I
*.PININFO wdata_asic[213]:I wdata_asic[212]:I wdata_asic[211]:I
*.PININFO wdata_asic[210]:I wdata_asic[209]:I wdata_asic[208]:I
*.PININFO wdata_asic[207]:I wdata_asic[206]:I wdata_asic[205]:I
*.PININFO wdata_asic[204]:I wdata_asic[203]:I wdata_asic[202]:I
*.PININFO wdata_asic[201]:I wdata_asic[200]:I wdata_asic[199]:I
*.PININFO wdata_asic[198]:I wdata_asic[197]:I wdata_asic[196]:I
*.PININFO wdata_asic[195]:I wdata_asic[194]:I wdata_asic[193]:I
*.PININFO wdata_asic[192]:I wdata_asic[191]:I wdata_asic[190]:I
*.PININFO wdata_asic[189]:I wdata_asic[188]:I wdata_asic[187]:I
*.PININFO wdata_asic[186]:I wdata_asic[185]:I wdata_asic[184]:I
*.PININFO wdata_asic[183]:I wdata_asic[182]:I wdata_asic[181]:I
*.PININFO wdata_asic[180]:I wdata_asic[179]:I wdata_asic[178]:I
*.PININFO wdata_asic[177]:I wdata_asic[176]:I wdata_asic[175]:I
*.PININFO wdata_asic[174]:I wdata_asic[173]:I wdata_asic[172]:I
*.PININFO wdata_asic[171]:I wdata_asic[170]:I wdata_asic[169]:I
*.PININFO wdata_asic[168]:I wdata_asic[167]:I wdata_asic[166]:I
*.PININFO wdata_asic[165]:I wdata_asic[164]:I wdata_asic[163]:I
*.PININFO wdata_asic[162]:I wdata_asic[161]:I wdata_asic[160]:I
*.PININFO wdata_asic[159]:I wdata_asic[158]:I wdata_asic[157]:I
*.PININFO wdata_asic[156]:I wdata_asic[155]:I wdata_asic[154]:I
*.PININFO wdata_asic[153]:I wdata_asic[152]:I wdata_asic[151]:I
*.PININFO wdata_asic[150]:I wdata_asic[149]:I wdata_asic[148]:I
*.PININFO wdata_asic[147]:I wdata_asic[146]:I wdata_asic[145]:I
*.PININFO wdata_asic[144]:I wdata_asic[143]:I wdata_asic[142]:I
*.PININFO wdata_asic[141]:I wdata_asic[140]:I wdata_asic[139]:I
*.PININFO wdata_asic[138]:I wdata_asic[137]:I wdata_asic[136]:I
*.PININFO wdata_asic[135]:I wdata_asic[134]:I wdata_asic[133]:I
*.PININFO wdata_asic[132]:I wdata_asic[131]:I wdata_asic[130]:I
*.PININFO wdata_asic[129]:I wdata_asic[128]:I wdata_asic[127]:I
*.PININFO wdata_asic[126]:I wdata_asic[125]:I wdata_asic[124]:I
*.PININFO wdata_asic[123]:I wdata_asic[122]:I wdata_asic[121]:I
*.PININFO wdata_asic[120]:I wdata_asic[119]:I wdata_asic[118]:I
*.PININFO wdata_asic[117]:I wdata_asic[116]:I wdata_asic[115]:I
*.PININFO wdata_asic[114]:I wdata_asic[113]:I wdata_asic[112]:I
*.PININFO wdata_asic[111]:I wdata_asic[110]:I wdata_asic[109]:I
*.PININFO wdata_asic[108]:I wdata_asic[107]:I wdata_asic[106]:I
*.PININFO wdata_asic[105]:I wdata_asic[104]:I wdata_asic[103]:I
*.PININFO wdata_asic[102]:I wdata_asic[101]:I wdata_asic[100]:I
*.PININFO wdata_asic[99]:I wdata_asic[98]:I wdata_asic[97]:I wdata_asic[96]:I
*.PININFO wdata_asic[95]:I wdata_asic[94]:I wdata_asic[93]:I wdata_asic[92]:I
*.PININFO wdata_asic[91]:I wdata_asic[90]:I wdata_asic[89]:I wdata_asic[88]:I
*.PININFO wdata_asic[87]:I wdata_asic[86]:I wdata_asic[85]:I wdata_asic[84]:I
*.PININFO wdata_asic[83]:I wdata_asic[82]:I wdata_asic[81]:I wdata_asic[80]:I
*.PININFO wdata_asic[79]:I wdata_asic[78]:I wdata_asic[77]:I wdata_asic[76]:I
*.PININFO wdata_asic[75]:I wdata_asic[74]:I wdata_asic[73]:I wdata_asic[72]:I
*.PININFO wdata_asic[71]:I wdata_asic[70]:I wdata_asic[69]:I wdata_asic[68]:I
*.PININFO wdata_asic[67]:I wdata_asic[66]:I wdata_asic[65]:I wdata_asic[64]:I
*.PININFO wdata_asic[63]:I wdata_asic[62]:I wdata_asic[61]:I wdata_asic[60]:I
*.PININFO wdata_asic[59]:I wdata_asic[58]:I wdata_asic[57]:I wdata_asic[56]:I
*.PININFO wdata_asic[55]:I wdata_asic[54]:I wdata_asic[53]:I wdata_asic[52]:I
*.PININFO wdata_asic[51]:I wdata_asic[50]:I wdata_asic[49]:I wdata_asic[48]:I
*.PININFO wdata_asic[47]:I wdata_asic[46]:I wdata_asic[45]:I wdata_asic[44]:I
*.PININFO wdata_asic[43]:I wdata_asic[42]:I wdata_asic[41]:I wdata_asic[40]:I
*.PININFO wdata_asic[39]:I wdata_asic[38]:I wdata_asic[37]:I wdata_asic[36]:I
*.PININFO wdata_asic[35]:I wdata_asic[34]:I wdata_asic[33]:I wdata_asic[32]:I
*.PININFO wdata_asic[31]:I wdata_asic[30]:I wdata_asic[29]:I wdata_asic[28]:I
*.PININFO wdata_asic[27]:I wdata_asic[26]:I wdata_asic[25]:I wdata_asic[24]:I
*.PININFO wdata_asic[23]:I wdata_asic[22]:I wdata_asic[21]:I wdata_asic[20]:I
*.PININFO wdata_asic[19]:I wdata_asic[18]:I wdata_asic[17]:I wdata_asic[16]:I
*.PININFO wdata_asic[15]:I wdata_asic[14]:I wdata_asic[13]:I wdata_asic[12]:I
*.PININFO wdata_asic[11]:I wdata_asic[10]:I wdata_asic[9]:I wdata_asic[8]:I
*.PININFO wdata_asic[7]:I wdata_asic[6]:I wdata_asic[5]:I wdata_asic[4]:I
*.PININFO wdata_asic[3]:I wdata_asic[2]:I wdata_asic[1]:I wdata_asic[0]:I
*.PININFO wdata_oe_asic:I bnksel_n_array_0:O bnksel_n_array_1:O
*.PININFO gcadd_array[7]:O gcadd_array[6]:O gcadd_array[5]:O gcadd_array[4]:O
*.PININFO gcadd_array[3]:O gcadd_array[2]:O gcadd_array[1]:O gcadd_array[0]:O
*.PININFO gcas_rd_array_0:O gcas_rd_array_1:O gcas_wr_array_0:O
*.PININFO gcas_wr_array_1:O gradd_array[12]:O gradd_array[11]:O
*.PININFO gradd_array[10]:O gradd_array[9]:O gradd_array[8]:O gradd_array[7]:O
*.PININFO gradd_array[6]:O gradd_array[5]:O gradd_array[4]:O gradd_array[3]:O
*.PININFO gradd_array[2]:O gradd_array[1]:O gradd_array[0]:O rdata_asic[271]:O
*.PININFO rdata_asic[270]:O rdata_asic[269]:O rdata_asic[268]:O
*.PININFO rdata_asic[267]:O rdata_asic[266]:O rdata_asic[265]:O
*.PININFO rdata_asic[264]:O rdata_asic[263]:O rdata_asic[262]:O
*.PININFO rdata_asic[261]:O rdata_asic[260]:O rdata_asic[259]:O
*.PININFO rdata_asic[258]:O rdata_asic[257]:O rdata_asic[256]:O
*.PININFO rdata_asic[255]:O rdata_asic[254]:O rdata_asic[253]:O
*.PININFO rdata_asic[252]:O rdata_asic[251]:O rdata_asic[250]:O
*.PININFO rdata_asic[249]:O rdata_asic[248]:O rdata_asic[247]:O
*.PININFO rdata_asic[246]:O rdata_asic[245]:O rdata_asic[244]:O
*.PININFO rdata_asic[243]:O rdata_asic[242]:O rdata_asic[241]:O
*.PININFO rdata_asic[240]:O rdata_asic[239]:O rdata_asic[238]:O
*.PININFO rdata_asic[237]:O rdata_asic[236]:O rdata_asic[235]:O
*.PININFO rdata_asic[234]:O rdata_asic[233]:O rdata_asic[232]:O
*.PININFO rdata_asic[231]:O rdata_asic[230]:O rdata_asic[229]:O
*.PININFO rdata_asic[228]:O rdata_asic[227]:O rdata_asic[226]:O
*.PININFO rdata_asic[225]:O rdata_asic[224]:O rdata_asic[223]:O
*.PININFO rdata_asic[222]:O rdata_asic[221]:O rdata_asic[220]:O
*.PININFO rdata_asic[219]:O rdata_asic[218]:O rdata_asic[217]:O
*.PININFO rdata_asic[216]:O rdata_asic[215]:O rdata_asic[214]:O
*.PININFO rdata_asic[213]:O rdata_asic[212]:O rdata_asic[211]:O
*.PININFO rdata_asic[210]:O rdata_asic[209]:O rdata_asic[208]:O
*.PININFO rdata_asic[207]:O rdata_asic[206]:O rdata_asic[205]:O
*.PININFO rdata_asic[204]:O rdata_asic[203]:O rdata_asic[202]:O
*.PININFO rdata_asic[201]:O rdata_asic[200]:O rdata_asic[199]:O
*.PININFO rdata_asic[198]:O rdata_asic[197]:O rdata_asic[196]:O
*.PININFO rdata_asic[195]:O rdata_asic[194]:O rdata_asic[193]:O
*.PININFO rdata_asic[192]:O rdata_asic[191]:O rdata_asic[190]:O
*.PININFO rdata_asic[189]:O rdata_asic[188]:O rdata_asic[187]:O
*.PININFO rdata_asic[186]:O rdata_asic[185]:O rdata_asic[184]:O
*.PININFO rdata_asic[183]:O rdata_asic[182]:O rdata_asic[181]:O
*.PININFO rdata_asic[180]:O rdata_asic[179]:O rdata_asic[178]:O
*.PININFO rdata_asic[177]:O rdata_asic[176]:O rdata_asic[175]:O
*.PININFO rdata_asic[174]:O rdata_asic[173]:O rdata_asic[172]:O
*.PININFO rdata_asic[171]:O rdata_asic[170]:O rdata_asic[169]:O
*.PININFO rdata_asic[168]:O rdata_asic[167]:O rdata_asic[166]:O
*.PININFO rdata_asic[165]:O rdata_asic[164]:O rdata_asic[163]:O
*.PININFO rdata_asic[162]:O rdata_asic[161]:O rdata_asic[160]:O
*.PININFO rdata_asic[159]:O rdata_asic[158]:O rdata_asic[157]:O
*.PININFO rdata_asic[156]:O rdata_asic[155]:O rdata_asic[154]:O
*.PININFO rdata_asic[153]:O rdata_asic[152]:O rdata_asic[151]:O
*.PININFO rdata_asic[150]:O rdata_asic[149]:O rdata_asic[148]:O
*.PININFO rdata_asic[147]:O rdata_asic[146]:O rdata_asic[145]:O
*.PININFO rdata_asic[144]:O rdata_asic[143]:O rdata_asic[142]:O
*.PININFO rdata_asic[141]:O rdata_asic[140]:O rdata_asic[139]:O
*.PININFO rdata_asic[138]:O rdata_asic[137]:O rdata_asic[136]:O
*.PININFO rdata_asic[135]:O rdata_asic[134]:O rdata_asic[133]:O
*.PININFO rdata_asic[132]:O rdata_asic[131]:O rdata_asic[130]:O
*.PININFO rdata_asic[129]:O rdata_asic[128]:O rdata_asic[127]:O
*.PININFO rdata_asic[126]:O rdata_asic[125]:O rdata_asic[124]:O
*.PININFO rdata_asic[123]:O rdata_asic[122]:O rdata_asic[121]:O
*.PININFO rdata_asic[120]:O rdata_asic[119]:O rdata_asic[118]:O
*.PININFO rdata_asic[117]:O rdata_asic[116]:O rdata_asic[115]:O
*.PININFO rdata_asic[114]:O rdata_asic[113]:O rdata_asic[112]:O
*.PININFO rdata_asic[111]:O rdata_asic[110]:O rdata_asic[109]:O
*.PININFO rdata_asic[108]:O rdata_asic[107]:O rdata_asic[106]:O
*.PININFO rdata_asic[105]:O rdata_asic[104]:O rdata_asic[103]:O
*.PININFO rdata_asic[102]:O rdata_asic[101]:O rdata_asic[100]:O
*.PININFO rdata_asic[99]:O rdata_asic[98]:O rdata_asic[97]:O rdata_asic[96]:O
*.PININFO rdata_asic[95]:O rdata_asic[94]:O rdata_asic[93]:O rdata_asic[92]:O
*.PININFO rdata_asic[91]:O rdata_asic[90]:O rdata_asic[89]:O rdata_asic[88]:O
*.PININFO rdata_asic[87]:O rdata_asic[86]:O rdata_asic[85]:O rdata_asic[84]:O
*.PININFO rdata_asic[83]:O rdata_asic[82]:O rdata_asic[81]:O rdata_asic[80]:O
*.PININFO rdata_asic[79]:O rdata_asic[78]:O rdata_asic[77]:O rdata_asic[76]:O
*.PININFO rdata_asic[75]:O rdata_asic[74]:O rdata_asic[73]:O rdata_asic[72]:O
*.PININFO rdata_asic[71]:O rdata_asic[70]:O rdata_asic[69]:O rdata_asic[68]:O
*.PININFO rdata_asic[67]:O rdata_asic[66]:O rdata_asic[65]:O rdata_asic[64]:O
*.PININFO rdata_asic[63]:O rdata_asic[62]:O rdata_asic[61]:O rdata_asic[60]:O
*.PININFO rdata_asic[59]:O rdata_asic[58]:O rdata_asic[57]:O rdata_asic[56]:O
*.PININFO rdata_asic[55]:O rdata_asic[54]:O rdata_asic[53]:O rdata_asic[52]:O
*.PININFO rdata_asic[51]:O rdata_asic[50]:O rdata_asic[49]:O rdata_asic[48]:O
*.PININFO rdata_asic[47]:O rdata_asic[46]:O rdata_asic[45]:O rdata_asic[44]:O
*.PININFO rdata_asic[43]:O rdata_asic[42]:O rdata_asic[41]:O rdata_asic[40]:O
*.PININFO rdata_asic[39]:O rdata_asic[38]:O rdata_asic[37]:O rdata_asic[36]:O
*.PININFO rdata_asic[35]:O rdata_asic[34]:O rdata_asic[33]:O rdata_asic[32]:O
*.PININFO rdata_asic[31]:O rdata_asic[30]:O rdata_asic[29]:O rdata_asic[28]:O
*.PININFO rdata_asic[27]:O rdata_asic[26]:O rdata_asic[25]:O rdata_asic[24]:O
*.PININFO rdata_asic[23]:O rdata_asic[22]:O rdata_asic[21]:O rdata_asic[20]:O
*.PININFO rdata_asic[19]:O rdata_asic[18]:O rdata_asic[17]:O rdata_asic[16]:O
*.PININFO rdata_asic[15]:O rdata_asic[14]:O rdata_asic[13]:O rdata_asic[12]:O
*.PININFO rdata_asic[11]:O rdata_asic[10]:O rdata_asic[9]:O rdata_asic[8]:O
*.PININFO rdata_asic[7]:O rdata_asic[6]:O rdata_asic[5]:O rdata_asic[4]:O
*.PININFO rdata_asic[3]:O rdata_asic[2]:O rdata_asic[1]:O rdata_asic[0]:O
*.PININFO rdrdy_n_asic:O reset_n_array:O rwdl_array[271]:B rwdl_array[270]:B
*.PININFO rwdl_array[269]:B rwdl_array[268]:B rwdl_array[267]:B
*.PININFO rwdl_array[266]:B rwdl_array[265]:B rwdl_array[264]:B
*.PININFO rwdl_array[263]:B rwdl_array[262]:B rwdl_array[261]:B
*.PININFO rwdl_array[260]:B rwdl_array[259]:B rwdl_array[258]:B
*.PININFO rwdl_array[257]:B rwdl_array[256]:B rwdl_array[255]:B
*.PININFO rwdl_array[254]:B rwdl_array[253]:B rwdl_array[252]:B
*.PININFO rwdl_array[251]:B rwdl_array[250]:B rwdl_array[249]:B
*.PININFO rwdl_array[248]:B rwdl_array[247]:B rwdl_array[246]:B
*.PININFO rwdl_array[245]:B rwdl_array[244]:B rwdl_array[243]:B
*.PININFO rwdl_array[242]:B rwdl_array[241]:B rwdl_array[240]:B
*.PININFO rwdl_array[239]:B rwdl_array[238]:B rwdl_array[237]:B
*.PININFO rwdl_array[236]:B rwdl_array[235]:B rwdl_array[234]:B
*.PININFO rwdl_array[233]:B rwdl_array[232]:B rwdl_array[231]:B
*.PININFO rwdl_array[230]:B rwdl_array[229]:B rwdl_array[228]:B
*.PININFO rwdl_array[227]:B rwdl_array[226]:B rwdl_array[225]:B
*.PININFO rwdl_array[224]:B rwdl_array[223]:B rwdl_array[222]:B
*.PININFO rwdl_array[221]:B rwdl_array[220]:B rwdl_array[219]:B
*.PININFO rwdl_array[218]:B rwdl_array[217]:B rwdl_array[216]:B
*.PININFO rwdl_array[215]:B rwdl_array[214]:B rwdl_array[213]:B
*.PININFO rwdl_array[212]:B rwdl_array[211]:B rwdl_array[210]:B
*.PININFO rwdl_array[209]:B rwdl_array[208]:B rwdl_array[207]:B
*.PININFO rwdl_array[206]:B rwdl_array[205]:B rwdl_array[204]:B
*.PININFO rwdl_array[203]:B rwdl_array[202]:B rwdl_array[201]:B
*.PININFO rwdl_array[200]:B rwdl_array[199]:B rwdl_array[198]:B
*.PININFO rwdl_array[197]:B rwdl_array[196]:B rwdl_array[195]:B
*.PININFO rwdl_array[194]:B rwdl_array[193]:B rwdl_array[192]:B
*.PININFO rwdl_array[191]:B rwdl_array[190]:B rwdl_array[189]:B
*.PININFO rwdl_array[188]:B rwdl_array[187]:B rwdl_array[186]:B
*.PININFO rwdl_array[185]:B rwdl_array[184]:B rwdl_array[183]:B
*.PININFO rwdl_array[182]:B rwdl_array[181]:B rwdl_array[180]:B
*.PININFO rwdl_array[179]:B rwdl_array[178]:B rwdl_array[177]:B
*.PININFO rwdl_array[176]:B rwdl_array[175]:B rwdl_array[174]:B
*.PININFO rwdl_array[173]:B rwdl_array[172]:B rwdl_array[171]:B
*.PININFO rwdl_array[170]:B rwdl_array[169]:B rwdl_array[168]:B
*.PININFO rwdl_array[167]:B rwdl_array[166]:B rwdl_array[165]:B
*.PININFO rwdl_array[164]:B rwdl_array[163]:B rwdl_array[162]:B
*.PININFO rwdl_array[161]:B rwdl_array[160]:B rwdl_array[159]:B
*.PININFO rwdl_array[158]:B rwdl_array[157]:B rwdl_array[156]:B
*.PININFO rwdl_array[155]:B rwdl_array[154]:B rwdl_array[153]:B
*.PININFO rwdl_array[152]:B rwdl_array[151]:B rwdl_array[150]:B
*.PININFO rwdl_array[149]:B rwdl_array[148]:B rwdl_array[147]:B
*.PININFO rwdl_array[146]:B rwdl_array[145]:B rwdl_array[144]:B
*.PININFO rwdl_array[143]:B rwdl_array[142]:B rwdl_array[141]:B
*.PININFO rwdl_array[140]:B rwdl_array[139]:B rwdl_array[138]:B
*.PININFO rwdl_array[137]:B rwdl_array[136]:B rwdl_array[135]:B
*.PININFO rwdl_array[134]:B rwdl_array[133]:B rwdl_array[132]:B
*.PININFO rwdl_array[131]:B rwdl_array[130]:B rwdl_array[129]:B
*.PININFO rwdl_array[128]:B rwdl_array[127]:B rwdl_array[126]:B
*.PININFO rwdl_array[125]:B rwdl_array[124]:B rwdl_array[123]:B
*.PININFO rwdl_array[122]:B rwdl_array[121]:B rwdl_array[120]:B
*.PININFO rwdl_array[119]:B rwdl_array[118]:B rwdl_array[117]:B
*.PININFO rwdl_array[116]:B rwdl_array[115]:B rwdl_array[114]:B
*.PININFO rwdl_array[113]:B rwdl_array[112]:B rwdl_array[111]:B
*.PININFO rwdl_array[110]:B rwdl_array[109]:B rwdl_array[108]:B
*.PININFO rwdl_array[107]:B rwdl_array[106]:B rwdl_array[105]:B
*.PININFO rwdl_array[104]:B rwdl_array[103]:B rwdl_array[102]:B
*.PININFO rwdl_array[101]:B rwdl_array[100]:B rwdl_array[99]:B
*.PININFO rwdl_array[98]:B rwdl_array[97]:B rwdl_array[96]:B rwdl_array[95]:B
*.PININFO rwdl_array[94]:B rwdl_array[93]:B rwdl_array[92]:B rwdl_array[91]:B
*.PININFO rwdl_array[90]:B rwdl_array[89]:B rwdl_array[88]:B rwdl_array[87]:B
*.PININFO rwdl_array[86]:B rwdl_array[85]:B rwdl_array[84]:B rwdl_array[83]:B
*.PININFO rwdl_array[82]:B rwdl_array[81]:B rwdl_array[80]:B rwdl_array[79]:B
*.PININFO rwdl_array[78]:B rwdl_array[77]:B rwdl_array[76]:B rwdl_array[75]:B
*.PININFO rwdl_array[74]:B rwdl_array[73]:B rwdl_array[72]:B rwdl_array[71]:B
*.PININFO rwdl_array[70]:B rwdl_array[69]:B rwdl_array[68]:B rwdl_array[67]:B
*.PININFO rwdl_array[66]:B rwdl_array[65]:B rwdl_array[64]:B rwdl_array[63]:B
*.PININFO rwdl_array[62]:B rwdl_array[61]:B rwdl_array[60]:B rwdl_array[59]:B
*.PININFO rwdl_array[58]:B rwdl_array[57]:B rwdl_array[56]:B rwdl_array[55]:B
*.PININFO rwdl_array[54]:B rwdl_array[53]:B rwdl_array[52]:B rwdl_array[51]:B
*.PININFO rwdl_array[50]:B rwdl_array[49]:B rwdl_array[48]:B rwdl_array[47]:B
*.PININFO rwdl_array[46]:B rwdl_array[45]:B rwdl_array[44]:B rwdl_array[43]:B
*.PININFO rwdl_array[42]:B rwdl_array[41]:B rwdl_array[40]:B rwdl_array[39]:B
*.PININFO rwdl_array[38]:B rwdl_array[37]:B rwdl_array[36]:B rwdl_array[35]:B
*.PININFO rwdl_array[34]:B rwdl_array[33]:B rwdl_array[32]:B rwdl_array[31]:B
*.PININFO rwdl_array[30]:B rwdl_array[29]:B rwdl_array[28]:B rwdl_array[27]:B
*.PININFO rwdl_array[26]:B rwdl_array[25]:B rwdl_array[24]:B rwdl_array[23]:B
*.PININFO rwdl_array[22]:B rwdl_array[21]:B rwdl_array[20]:B rwdl_array[19]:B
*.PININFO rwdl_array[18]:B rwdl_array[17]:B rwdl_array[16]:B rwdl_array[15]:B
*.PININFO rwdl_array[14]:B rwdl_array[13]:B rwdl_array[12]:B rwdl_array[11]:B
*.PININFO rwdl_array[10]:B rwdl_array[9]:B rwdl_array[8]:B rwdl_array[7]:B
*.PININFO rwdl_array[6]:B rwdl_array[5]:B rwdl_array[4]:B rwdl_array[3]:B
*.PININFO rwdl_array[2]:B rwdl_array[1]:B rwdl_array[0]:B vdd:B vdd_array:B
*.PININFO vss:B
Xi241<1> net497 vdd vss net084 / BUFFD6BWP7T30P140
Xi241<0> net497 vdd vss net084 / BUFFD6BWP7T30P140
Xi239 net379 vdd vss clk_gcadd / BUFFD6BWP7T30P140
Xi321 rdrdy_n_array_0 rdrdy_n_array_1 net8 vdd_array vss / and_array
Xi352<1> cfg_dly_gcas_wr_1[1] vdd vss net36[1] / BUFFD4BWP7T30P140
Xi352<0> cfg_dly_gcas_wr_1[0] vdd vss net36[0] / BUFFD4BWP7T30P140
Xi358<1> asic_out_en_ff vdd vss net14 / BUFFD4BWP7T30P140
Xi358<0> asic_out_en_ff vdd vss net14 / BUFFD4BWP7T30P140
Xi325<1> cfg_dly_bnksel_n_1[1] vdd vss net13[1] / BUFFD4BWP7T30P140
Xi325<0> cfg_dly_bnksel_n_1[0] vdd vss net13[0] / BUFFD4BWP7T30P140
Xi268<1> cfg_dly_bnksel_n_0[1] vdd vss net512[1] / BUFFD4BWP7T30P140
Xi268<0> cfg_dly_bnksel_n_0[0] vdd vss net512[0] / BUFFD4BWP7T30P140
Xi262<1> cfg_dly_gcadd[1] vdd vss net508[1] / BUFFD4BWP7T30P140
Xi262<0> cfg_dly_gcadd[0] vdd vss net508[0] / BUFFD4BWP7T30P140
Xi257<1> cfg_dly_gcas_wr_0[1] vdd vss net509[1] / BUFFD4BWP7T30P140
Xi257<0> cfg_dly_gcas_wr_0[0] vdd vss net509[0] / BUFFD4BWP7T30P140
Xi264<1> cfg_dly_gcas_rd_0[1] vdd vss net510[1] / BUFFD4BWP7T30P140
Xi264<0> cfg_dly_gcas_rd_0[0] vdd vss net510[0] / BUFFD4BWP7T30P140
Xi240 ls_en_asic vdd vss net497 / BUFFD4BWP7T30P140
Xi232 net393 vdd vss clk_bnksel / BUFFD4BWP7T30P140
Xi231 net393 vdd vss clk_gradd / BUFFD4BWP7T30P140
Xi238 net379 vdd vss net393 / BUFFD4BWP7T30P140
Xi340<1> cfg_dly_gcas_rd_1[1] vdd vss net33[1] / BUFFD4BWP7T30P140
Xi340<0> cfg_dly_gcas_rd_1[0] vdd vss net33[0] / BUFFD4BWP7T30P140
Xi225 clk_asic_out_en vdd vss net496 / BUFFD4BWP7T30P140
Xi329 clk_bnksel net15 bnksel_n_d0_ff_1 ls_en_drv3 vdd vss / DFSNQD1BWP7T30P140
Xcc_bnksel_n_reg clk_bnksel net2 bnksel_n_d0_ff_0 ls_en_drv3 vdd vss /
+ DFSNQD1BWP7T30P140
Xi134 vdd vss tiehi_1 / TIEHBWP7T30P140
Xi355 vdd_array vss gcas_wr_dly_1 gcas_wr_array_1 vdd vss /
+ Levelshift_1p1buf_nom
Xlv_gcas_rd vdd_array vss gcas_rd_dly_0 gcas_rd_array_0 vdd vss /
+ Levelshift_1p1buf_nom
Xlv_gcas_wr vdd_array vss gcas_wr_dly_0 gcas_wr_array_0 vdd vss /
+ Levelshift_1p1buf_nom
Xlv_gcadd<7> vdd_array vss net0641[7] gcadd_array[7] vdd vss /
+ Levelshift_1p1buf_nom
Xlv_gcadd<6> vdd_array vss net0641[6] gcadd_array[6] vdd vss /
+ Levelshift_1p1buf_nom
Xlv_gcadd<5> vdd_array vss net0641[5] gcadd_array[5] vdd vss /
+ Levelshift_1p1buf_nom
Xlv_gcadd<4> vdd_array vss net0641[4] gcadd_array[4] vdd vss /
+ Levelshift_1p1buf_nom
Xlv_gcadd<3> vdd_array vss net0641[3] gcadd_array[3] vdd vss /
+ Levelshift_1p1buf_nom
Xlv_gcadd<2> vdd_array vss net0641[2] gcadd_array[2] vdd vss /
+ Levelshift_1p1buf_nom
Xlv_gcadd<1> vdd_array vss net0641[1] gcadd_array[1] vdd vss /
+ Levelshift_1p1buf_nom
Xlv_gcadd<0> vdd_array vss net0641[0] gcadd_array[0] vdd vss /
+ Levelshift_1p1buf_nom
Xi343 vdd_array vss gcas_rd_dly_1 gcas_rd_array_1 vdd vss /
+ Levelshift_1p1buf_nom
Xi348 gcas_wr_en_asic_1 vdd vss net46 / BUFFD3BWP7T30P140
Xi258 gcas_wr_en_asic_0 vdd vss net483 / BUFFD3BWP7T30P140
Xi263<7> gcadd_asic[7] vdd vss net27[7] / BUFFD3BWP7T30P140
Xi263<6> gcadd_asic[6] vdd vss net27[6] / BUFFD3BWP7T30P140
Xi263<5> gcadd_asic[5] vdd vss net27[5] / BUFFD3BWP7T30P140
Xi263<4> gcadd_asic[4] vdd vss net27[4] / BUFFD3BWP7T30P140
Xi263<3> gcadd_asic[3] vdd vss net27[3] / BUFFD3BWP7T30P140
Xi263<2> gcadd_asic[2] vdd vss net27[2] / BUFFD3BWP7T30P140
Xi263<1> gcadd_asic[1] vdd vss net27[1] / BUFFD3BWP7T30P140
Xi263<0> gcadd_asic[0] vdd vss net27[0] / BUFFD3BWP7T30P140
Xi269 bnksel_n_asic_0 vdd vss net2 / BUFFD3BWP7T30P140
Xi273<12> gradd_asic[12] vdd vss net28[12] / BUFFD3BWP7T30P140
Xi273<11> gradd_asic[11] vdd vss net28[11] / BUFFD3BWP7T30P140
Xi273<10> gradd_asic[10] vdd vss net28[10] / BUFFD3BWP7T30P140
Xi273<9> gradd_asic[9] vdd vss net28[9] / BUFFD3BWP7T30P140
Xi273<8> gradd_asic[8] vdd vss net28[8] / BUFFD3BWP7T30P140
Xi273<7> gradd_asic[7] vdd vss net28[7] / BUFFD3BWP7T30P140
Xi273<6> gradd_asic[6] vdd vss net28[6] / BUFFD3BWP7T30P140
Xi273<5> gradd_asic[5] vdd vss net28[5] / BUFFD3BWP7T30P140
Xi273<4> gradd_asic[4] vdd vss net28[4] / BUFFD3BWP7T30P140
Xi273<3> gradd_asic[3] vdd vss net28[3] / BUFFD3BWP7T30P140
Xi273<2> gradd_asic[2] vdd vss net28[2] / BUFFD3BWP7T30P140
Xi273<1> gradd_asic[1] vdd vss net28[1] / BUFFD3BWP7T30P140
Xi273<0> gradd_asic[0] vdd vss net28[0] / BUFFD3BWP7T30P140
Xi328 bnksel_n_asic_1 vdd vss net15 / BUFFD3BWP7T30P140
Xi265 gcas_rd_en_asic_0 vdd vss net481 / BUFFD3BWP7T30P140
Xi334 gcas_rd_en_asic_1 vdd vss net21 / BUFFD3BWP7T30P140
Xi251 wdata_oe_asic vdd vss net64 / BUFFD3BWP7T30P140
Xi353 gcas_wr_ff_buf_1 gcas_wr_dly_1 net44 net43 net42 net41 net40 net39 net38
+ net37 vdd vss / hb_macro_dly
Xgcas_rd_dly_u gcas_rd_ff_buf_0 gcas_rd_dly_0 net463 net458 net453 net459
+ net460 net461 net457 net462 vdd vss / hb_macro_dly
Xgcas_wr_dly_u gcas_wr_ff_buf_0 gcas_wr_dly_0 net447 net446 net445 net444
+ net443 net442 net441 net440 vdd vss / hb_macro_dly
Xgcadd_wr_dly_u<7> gcadd_ff[7] net0641[7] sel_0_wr sel_0_n_wr sel_1_wr
+ sel_1_n_wr sel_2_wr sel_2_n_wr sel_3_wr sel_3_n_wr vdd vss / hb_macro_dly
Xgcadd_wr_dly_u<6> gcadd_ff[6] net0641[6] sel_0_wr sel_0_n_wr sel_1_wr
+ sel_1_n_wr sel_2_wr sel_2_n_wr sel_3_wr sel_3_n_wr vdd vss / hb_macro_dly
Xgcadd_wr_dly_u<5> gcadd_ff[5] net0641[5] sel_0_wr sel_0_n_wr sel_1_wr
+ sel_1_n_wr sel_2_wr sel_2_n_wr sel_3_wr sel_3_n_wr vdd vss / hb_macro_dly
Xgcadd_wr_dly_u<4> gcadd_ff[4] net0641[4] sel_0_wr sel_0_n_wr sel_1_wr
+ sel_1_n_wr sel_2_wr sel_2_n_wr sel_3_wr sel_3_n_wr vdd vss / hb_macro_dly
Xgcadd_wr_dly_u<3> gcadd_ff[3] net0641[3] sel_0_wr sel_0_n_wr sel_1_wr
+ sel_1_n_wr sel_2_wr sel_2_n_wr sel_3_wr sel_3_n_wr vdd vss / hb_macro_dly
Xgcadd_wr_dly_u<2> gcadd_ff[2] net0641[2] sel_0_wr sel_0_n_wr sel_1_wr
+ sel_1_n_wr sel_2_wr sel_2_n_wr sel_3_wr sel_3_n_wr vdd vss / hb_macro_dly
Xgcadd_wr_dly_u<1> gcadd_ff[1] net0641[1] sel_0_wr sel_0_n_wr sel_1_wr
+ sel_1_n_wr sel_2_wr sel_2_n_wr sel_3_wr sel_3_n_wr vdd vss / hb_macro_dly
Xgcadd_wr_dly_u<0> gcadd_ff[0] net0641[0] sel_0_wr sel_0_n_wr sel_1_wr
+ sel_1_n_wr sel_2_wr sel_2_n_wr sel_3_wr sel_3_n_wr vdd vss / hb_macro_dly
Xi341 gcas_rd_ff_buf_1 gcas_rd_dly_1 net31 net30 net29 net32 net26 net25 net24
+ net23 vdd vss / hb_macro_dly
Xi372<14> net63 vdd vss net61 / BUFFD16BWP7T30P140
Xi372<13> net63 vdd vss net61 / BUFFD16BWP7T30P140
Xi372<12> net63 vdd vss net61 / BUFFD16BWP7T30P140
Xi372<11> net63 vdd vss net61 / BUFFD16BWP7T30P140
Xi372<10> net63 vdd vss net61 / BUFFD16BWP7T30P140
Xi372<9> net63 vdd vss net61 / BUFFD16BWP7T30P140
Xi372<8> net63 vdd vss net61 / BUFFD16BWP7T30P140
Xi372<7> net63 vdd vss net61 / BUFFD16BWP7T30P140
Xi372<6> net63 vdd vss net61 / BUFFD16BWP7T30P140
Xi372<5> net63 vdd vss net61 / BUFFD16BWP7T30P140
Xi372<4> net63 vdd vss net61 / BUFFD16BWP7T30P140
Xi372<3> net63 vdd vss net61 / BUFFD16BWP7T30P140
Xi372<2> net63 vdd vss net61 / BUFFD16BWP7T30P140
Xi372<1> net63 vdd vss net61 / BUFFD16BWP7T30P140
Xi372<0> net63 vdd vss net61 / BUFFD16BWP7T30P140
Xi359<3> net14 vdd vss net499 / BUFFD16BWP7T30P140
Xi359<2> net14 vdd vss net499 / BUFFD16BWP7T30P140
Xi359<1> net14 vdd vss net499 / BUFFD16BWP7T30P140
Xi359<0> net14 vdd vss net499 / BUFFD16BWP7T30P140
Xi371<14> net58 vdd vss net62 / BUFFD16BWP7T30P140
Xi371<13> net58 vdd vss net62 / BUFFD16BWP7T30P140
Xi371<12> net58 vdd vss net62 / BUFFD16BWP7T30P140
Xi371<11> net58 vdd vss net62 / BUFFD16BWP7T30P140
Xi371<10> net58 vdd vss net62 / BUFFD16BWP7T30P140
Xi371<9> net58 vdd vss net62 / BUFFD16BWP7T30P140
Xi371<8> net58 vdd vss net62 / BUFFD16BWP7T30P140
Xi371<7> net58 vdd vss net62 / BUFFD16BWP7T30P140
Xi371<6> net58 vdd vss net62 / BUFFD16BWP7T30P140
Xi371<5> net58 vdd vss net62 / BUFFD16BWP7T30P140
Xi371<4> net58 vdd vss net62 / BUFFD16BWP7T30P140
Xi371<3> net58 vdd vss net62 / BUFFD16BWP7T30P140
Xi371<2> net58 vdd vss net62 / BUFFD16BWP7T30P140
Xi371<1> net58 vdd vss net62 / BUFFD16BWP7T30P140
Xi371<0> net58 vdd vss net62 / BUFFD16BWP7T30P140
Xi244 ls_en_drv1 vdd vss ls_en_drv3 / BUFFD16BWP7T30P140
Xi243 net084 vdd vss ls_en_drv1 / BUFFD16BWP7T30P140
Xi226 net496 vdd vss net387 / BUFFD16BWP7T30P140
Xasic_io_rwdl_0<135> rwdl_array[135] out_en[1] wdata_ff[135] rdata_asic[135]
+ vdd vdd_array vss vss / asic_io_p2
Xasic_io_rwdl_0<134> rwdl_array[134] out_en[1] wdata_ff[134] rdata_asic[134]
+ vdd vdd_array vss vss / asic_io_p2
Xasic_io_rwdl_0<133> rwdl_array[133] out_en[1] wdata_ff[133] rdata_asic[133]
+ vdd vdd_array vss vss / asic_io_p2
Xasic_io_rwdl_0<132> rwdl_array[132] out_en[1] wdata_ff[132] rdata_asic[132]
+ vdd vdd_array vss vss / asic_io_p2
Xasic_io_rwdl_0<131> rwdl_array[131] out_en[1] wdata_ff[131] rdata_asic[131]
+ vdd vdd_array vss vss / asic_io_p2
Xasic_io_rwdl_0<130> rwdl_array[130] out_en[1] wdata_ff[130] rdata_asic[130]
+ vdd vdd_array vss vss / asic_io_p2
Xasic_io_rwdl_0<129> rwdl_array[129] out_en[1] wdata_ff[129] rdata_asic[129]
+ vdd vdd_array vss vss / asic_io_p2
Xasic_io_rwdl_0<128> rwdl_array[128] out_en[1] wdata_ff[128] rdata_asic[128]
+ vdd vdd_array vss vss / asic_io_p2
Xasic_io_rwdl_0<127> rwdl_array[127] out_en[1] wdata_ff[127] rdata_asic[127]
+ vdd vdd_array vss vss / asic_io_p2
Xasic_io_rwdl_0<126> rwdl_array[126] out_en[1] wdata_ff[126] rdata_asic[126]
+ vdd vdd_array vss vss / asic_io_p2
Xasic_io_rwdl_0<125> rwdl_array[125] out_en[1] wdata_ff[125] rdata_asic[125]
+ vdd vdd_array vss vss / asic_io_p2
Xasic_io_rwdl_0<124> rwdl_array[124] out_en[1] wdata_ff[124] rdata_asic[124]
+ vdd vdd_array vss vss / asic_io_p2
Xasic_io_rwdl_0<123> rwdl_array[123] out_en[1] wdata_ff[123] rdata_asic[123]
+ vdd vdd_array vss vss / asic_io_p2
Xasic_io_rwdl_0<122> rwdl_array[122] out_en[1] wdata_ff[122] rdata_asic[122]
+ vdd vdd_array vss vss / asic_io_p2
Xasic_io_rwdl_0<121> rwdl_array[121] out_en[1] wdata_ff[121] rdata_asic[121]
+ vdd vdd_array vss vss / asic_io_p2
Xasic_io_rwdl_0<120> rwdl_array[120] out_en[1] wdata_ff[120] rdata_asic[120]
+ vdd vdd_array vss vss / asic_io_p2
Xasic_io_rwdl_0<119> rwdl_array[119] out_en[1] wdata_ff[119] rdata_asic[119]
+ vdd vdd_array vss vss / asic_io_p2
Xasic_io_rwdl_0<118> rwdl_array[118] out_en[1] wdata_ff[118] rdata_asic[118]
+ vdd vdd_array vss vss / asic_io_p2
Xasic_io_rwdl_0<117> rwdl_array[117] out_en[1] wdata_ff[117] rdata_asic[117]
+ vdd vdd_array vss vss / asic_io_p2
Xasic_io_rwdl_0<116> rwdl_array[116] out_en[1] wdata_ff[116] rdata_asic[116]
+ vdd vdd_array vss vss / asic_io_p2
Xasic_io_rwdl_0<115> rwdl_array[115] out_en[1] wdata_ff[115] rdata_asic[115]
+ vdd vdd_array vss vss / asic_io_p2
Xasic_io_rwdl_0<114> rwdl_array[114] out_en[1] wdata_ff[114] rdata_asic[114]
+ vdd vdd_array vss vss / asic_io_p2
Xasic_io_rwdl_0<113> rwdl_array[113] out_en[1] wdata_ff[113] rdata_asic[113]
+ vdd vdd_array vss vss / asic_io_p2
Xasic_io_rwdl_0<112> rwdl_array[112] out_en[1] wdata_ff[112] rdata_asic[112]
+ vdd vdd_array vss vss / asic_io_p2
Xasic_io_rwdl_0<111> rwdl_array[111] out_en[1] wdata_ff[111] rdata_asic[111]
+ vdd vdd_array vss vss / asic_io_p2
Xasic_io_rwdl_0<110> rwdl_array[110] out_en[1] wdata_ff[110] rdata_asic[110]
+ vdd vdd_array vss vss / asic_io_p2
Xasic_io_rwdl_0<109> rwdl_array[109] out_en[1] wdata_ff[109] rdata_asic[109]
+ vdd vdd_array vss vss / asic_io_p2
Xasic_io_rwdl_0<108> rwdl_array[108] out_en[1] wdata_ff[108] rdata_asic[108]
+ vdd vdd_array vss vss / asic_io_p2
Xasic_io_rwdl_0<107> rwdl_array[107] out_en[1] wdata_ff[107] rdata_asic[107]
+ vdd vdd_array vss vss / asic_io_p2
Xasic_io_rwdl_0<106> rwdl_array[106] out_en[1] wdata_ff[106] rdata_asic[106]
+ vdd vdd_array vss vss / asic_io_p2
Xasic_io_rwdl_0<105> rwdl_array[105] out_en[1] wdata_ff[105] rdata_asic[105]
+ vdd vdd_array vss vss / asic_io_p2
Xasic_io_rwdl_0<104> rwdl_array[104] out_en[1] wdata_ff[104] rdata_asic[104]
+ vdd vdd_array vss vss / asic_io_p2
Xasic_io_rwdl_0<103> rwdl_array[103] out_en[1] wdata_ff[103] rdata_asic[103]
+ vdd vdd_array vss vss / asic_io_p2
Xasic_io_rwdl_0<102> rwdl_array[102] out_en[1] wdata_ff[102] rdata_asic[102]
+ vdd vdd_array vss vss / asic_io_p2
Xasic_io_rwdl_0<101> rwdl_array[101] out_en[1] wdata_ff[101] rdata_asic[101]
+ vdd vdd_array vss vss / asic_io_p2
Xasic_io_rwdl_0<100> rwdl_array[100] out_en[1] wdata_ff[100] rdata_asic[100]
+ vdd vdd_array vss vss / asic_io_p2
Xasic_io_rwdl_0<99> rwdl_array[99] out_en[1] wdata_ff[99] rdata_asic[99] vdd
+ vdd_array vss vss / asic_io_p2
Xasic_io_rwdl_0<98> rwdl_array[98] out_en[1] wdata_ff[98] rdata_asic[98] vdd
+ vdd_array vss vss / asic_io_p2
Xasic_io_rwdl_0<97> rwdl_array[97] out_en[1] wdata_ff[97] rdata_asic[97] vdd
+ vdd_array vss vss / asic_io_p2
Xasic_io_rwdl_0<96> rwdl_array[96] out_en[1] wdata_ff[96] rdata_asic[96] vdd
+ vdd_array vss vss / asic_io_p2
Xasic_io_rwdl_0<95> rwdl_array[95] out_en[1] wdata_ff[95] rdata_asic[95] vdd
+ vdd_array vss vss / asic_io_p2
Xasic_io_rwdl_0<94> rwdl_array[94] out_en[1] wdata_ff[94] rdata_asic[94] vdd
+ vdd_array vss vss / asic_io_p2
Xasic_io_rwdl_0<93> rwdl_array[93] out_en[1] wdata_ff[93] rdata_asic[93] vdd
+ vdd_array vss vss / asic_io_p2
Xasic_io_rwdl_0<92> rwdl_array[92] out_en[1] wdata_ff[92] rdata_asic[92] vdd
+ vdd_array vss vss / asic_io_p2
Xasic_io_rwdl_0<91> rwdl_array[91] out_en[1] wdata_ff[91] rdata_asic[91] vdd
+ vdd_array vss vss / asic_io_p2
Xasic_io_rwdl_0<90> rwdl_array[90] out_en[1] wdata_ff[90] rdata_asic[90] vdd
+ vdd_array vss vss / asic_io_p2
Xasic_io_rwdl_0<89> rwdl_array[89] out_en[1] wdata_ff[89] rdata_asic[89] vdd
+ vdd_array vss vss / asic_io_p2
Xasic_io_rwdl_0<88> rwdl_array[88] out_en[1] wdata_ff[88] rdata_asic[88] vdd
+ vdd_array vss vss / asic_io_p2
Xasic_io_rwdl_0<87> rwdl_array[87] out_en[1] wdata_ff[87] rdata_asic[87] vdd
+ vdd_array vss vss / asic_io_p2
Xasic_io_rwdl_0<86> rwdl_array[86] out_en[1] wdata_ff[86] rdata_asic[86] vdd
+ vdd_array vss vss / asic_io_p2
Xasic_io_rwdl_0<85> rwdl_array[85] out_en[1] wdata_ff[85] rdata_asic[85] vdd
+ vdd_array vss vss / asic_io_p2
Xasic_io_rwdl_0<84> rwdl_array[84] out_en[1] wdata_ff[84] rdata_asic[84] vdd
+ vdd_array vss vss / asic_io_p2
Xasic_io_rwdl_0<83> rwdl_array[83] out_en[1] wdata_ff[83] rdata_asic[83] vdd
+ vdd_array vss vss / asic_io_p2
Xasic_io_rwdl_0<82> rwdl_array[82] out_en[1] wdata_ff[82] rdata_asic[82] vdd
+ vdd_array vss vss / asic_io_p2
Xasic_io_rwdl_0<81> rwdl_array[81] out_en[1] wdata_ff[81] rdata_asic[81] vdd
+ vdd_array vss vss / asic_io_p2
Xasic_io_rwdl_0<80> rwdl_array[80] out_en[1] wdata_ff[80] rdata_asic[80] vdd
+ vdd_array vss vss / asic_io_p2
Xasic_io_rwdl_0<79> rwdl_array[79] out_en[1] wdata_ff[79] rdata_asic[79] vdd
+ vdd_array vss vss / asic_io_p2
Xasic_io_rwdl_0<78> rwdl_array[78] out_en[1] wdata_ff[78] rdata_asic[78] vdd
+ vdd_array vss vss / asic_io_p2
Xasic_io_rwdl_0<77> rwdl_array[77] out_en[1] wdata_ff[77] rdata_asic[77] vdd
+ vdd_array vss vss / asic_io_p2
Xasic_io_rwdl_0<76> rwdl_array[76] out_en[1] wdata_ff[76] rdata_asic[76] vdd
+ vdd_array vss vss / asic_io_p2
Xasic_io_rwdl_0<75> rwdl_array[75] out_en[1] wdata_ff[75] rdata_asic[75] vdd
+ vdd_array vss vss / asic_io_p2
Xasic_io_rwdl_0<74> rwdl_array[74] out_en[1] wdata_ff[74] rdata_asic[74] vdd
+ vdd_array vss vss / asic_io_p2
Xasic_io_rwdl_0<73> rwdl_array[73] out_en[1] wdata_ff[73] rdata_asic[73] vdd
+ vdd_array vss vss / asic_io_p2
Xasic_io_rwdl_0<72> rwdl_array[72] out_en[1] wdata_ff[72] rdata_asic[72] vdd
+ vdd_array vss vss / asic_io_p2
Xasic_io_rwdl_0<71> rwdl_array[71] out_en[1] wdata_ff[71] rdata_asic[71] vdd
+ vdd_array vss vss / asic_io_p2
Xasic_io_rwdl_0<70> rwdl_array[70] out_en[1] wdata_ff[70] rdata_asic[70] vdd
+ vdd_array vss vss / asic_io_p2
Xasic_io_rwdl_0<69> rwdl_array[69] out_en[1] wdata_ff[69] rdata_asic[69] vdd
+ vdd_array vss vss / asic_io_p2
Xasic_io_rwdl_0<68> rwdl_array[68] out_en[1] wdata_ff[68] rdata_asic[68] vdd
+ vdd_array vss vss / asic_io_p2
Xasic_io_rwdl_0<67> rwdl_array[67] out_en[1] wdata_ff[67] rdata_asic[67] vdd
+ vdd_array vss vss / asic_io_p2
Xasic_io_rwdl_0<66> rwdl_array[66] out_en[1] wdata_ff[66] rdata_asic[66] vdd
+ vdd_array vss vss / asic_io_p2
Xasic_io_rwdl_0<65> rwdl_array[65] out_en[1] wdata_ff[65] rdata_asic[65] vdd
+ vdd_array vss vss / asic_io_p2
Xasic_io_rwdl_0<64> rwdl_array[64] out_en[1] wdata_ff[64] rdata_asic[64] vdd
+ vdd_array vss vss / asic_io_p2
Xasic_io_rwdl_0<63> rwdl_array[63] out_en[1] wdata_ff[63] rdata_asic[63] vdd
+ vdd_array vss vss / asic_io_p2
Xasic_io_rwdl_0<62> rwdl_array[62] out_en[1] wdata_ff[62] rdata_asic[62] vdd
+ vdd_array vss vss / asic_io_p2
Xasic_io_rwdl_0<61> rwdl_array[61] out_en[1] wdata_ff[61] rdata_asic[61] vdd
+ vdd_array vss vss / asic_io_p2
Xasic_io_rwdl_0<60> rwdl_array[60] out_en[1] wdata_ff[60] rdata_asic[60] vdd
+ vdd_array vss vss / asic_io_p2
Xasic_io_rwdl_0<59> rwdl_array[59] out_en[1] wdata_ff[59] rdata_asic[59] vdd
+ vdd_array vss vss / asic_io_p2
Xasic_io_rwdl_0<58> rwdl_array[58] out_en[1] wdata_ff[58] rdata_asic[58] vdd
+ vdd_array vss vss / asic_io_p2
Xasic_io_rwdl_0<57> rwdl_array[57] out_en[1] wdata_ff[57] rdata_asic[57] vdd
+ vdd_array vss vss / asic_io_p2
Xasic_io_rwdl_0<56> rwdl_array[56] out_en[1] wdata_ff[56] rdata_asic[56] vdd
+ vdd_array vss vss / asic_io_p2
Xasic_io_rwdl_0<55> rwdl_array[55] out_en[1] wdata_ff[55] rdata_asic[55] vdd
+ vdd_array vss vss / asic_io_p2
Xasic_io_rwdl_0<54> rwdl_array[54] out_en[1] wdata_ff[54] rdata_asic[54] vdd
+ vdd_array vss vss / asic_io_p2
Xasic_io_rwdl_0<53> rwdl_array[53] out_en[1] wdata_ff[53] rdata_asic[53] vdd
+ vdd_array vss vss / asic_io_p2
Xasic_io_rwdl_0<52> rwdl_array[52] out_en[1] wdata_ff[52] rdata_asic[52] vdd
+ vdd_array vss vss / asic_io_p2
Xasic_io_rwdl_0<51> rwdl_array[51] out_en[1] wdata_ff[51] rdata_asic[51] vdd
+ vdd_array vss vss / asic_io_p2
Xasic_io_rwdl_0<50> rwdl_array[50] out_en[1] wdata_ff[50] rdata_asic[50] vdd
+ vdd_array vss vss / asic_io_p2
Xasic_io_rwdl_0<49> rwdl_array[49] out_en[1] wdata_ff[49] rdata_asic[49] vdd
+ vdd_array vss vss / asic_io_p2
Xasic_io_rwdl_0<48> rwdl_array[48] out_en[1] wdata_ff[48] rdata_asic[48] vdd
+ vdd_array vss vss / asic_io_p2
Xasic_io_rwdl_0<47> rwdl_array[47] out_en[1] wdata_ff[47] rdata_asic[47] vdd
+ vdd_array vss vss / asic_io_p2
Xasic_io_rwdl_0<46> rwdl_array[46] out_en[1] wdata_ff[46] rdata_asic[46] vdd
+ vdd_array vss vss / asic_io_p2
Xasic_io_rwdl_0<45> rwdl_array[45] out_en[1] wdata_ff[45] rdata_asic[45] vdd
+ vdd_array vss vss / asic_io_p2
Xasic_io_rwdl_0<44> rwdl_array[44] out_en[1] wdata_ff[44] rdata_asic[44] vdd
+ vdd_array vss vss / asic_io_p2
Xasic_io_rwdl_0<43> rwdl_array[43] out_en[1] wdata_ff[43] rdata_asic[43] vdd
+ vdd_array vss vss / asic_io_p2
Xasic_io_rwdl_0<42> rwdl_array[42] out_en[1] wdata_ff[42] rdata_asic[42] vdd
+ vdd_array vss vss / asic_io_p2
Xasic_io_rwdl_0<41> rwdl_array[41] out_en[1] wdata_ff[41] rdata_asic[41] vdd
+ vdd_array vss vss / asic_io_p2
Xasic_io_rwdl_0<40> rwdl_array[40] out_en[1] wdata_ff[40] rdata_asic[40] vdd
+ vdd_array vss vss / asic_io_p2
Xasic_io_rwdl_0<39> rwdl_array[39] out_en[1] wdata_ff[39] rdata_asic[39] vdd
+ vdd_array vss vss / asic_io_p2
Xasic_io_rwdl_0<38> rwdl_array[38] out_en[1] wdata_ff[38] rdata_asic[38] vdd
+ vdd_array vss vss / asic_io_p2
Xasic_io_rwdl_0<37> rwdl_array[37] out_en[1] wdata_ff[37] rdata_asic[37] vdd
+ vdd_array vss vss / asic_io_p2
Xasic_io_rwdl_0<36> rwdl_array[36] out_en[1] wdata_ff[36] rdata_asic[36] vdd
+ vdd_array vss vss / asic_io_p2
Xasic_io_rwdl_0<35> rwdl_array[35] out_en[1] wdata_ff[35] rdata_asic[35] vdd
+ vdd_array vss vss / asic_io_p2
Xasic_io_rwdl_0<34> rwdl_array[34] out_en[1] wdata_ff[34] rdata_asic[34] vdd
+ vdd_array vss vss / asic_io_p2
Xasic_io_rwdl_0<33> rwdl_array[33] out_en[1] wdata_ff[33] rdata_asic[33] vdd
+ vdd_array vss vss / asic_io_p2
Xasic_io_rwdl_0<32> rwdl_array[32] out_en[1] wdata_ff[32] rdata_asic[32] vdd
+ vdd_array vss vss / asic_io_p2
Xasic_io_rwdl_0<31> rwdl_array[31] out_en[1] wdata_ff[31] rdata_asic[31] vdd
+ vdd_array vss vss / asic_io_p2
Xasic_io_rwdl_0<30> rwdl_array[30] out_en[1] wdata_ff[30] rdata_asic[30] vdd
+ vdd_array vss vss / asic_io_p2
Xasic_io_rwdl_0<29> rwdl_array[29] out_en[1] wdata_ff[29] rdata_asic[29] vdd
+ vdd_array vss vss / asic_io_p2
Xasic_io_rwdl_0<28> rwdl_array[28] out_en[1] wdata_ff[28] rdata_asic[28] vdd
+ vdd_array vss vss / asic_io_p2
Xasic_io_rwdl_0<27> rwdl_array[27] out_en[1] wdata_ff[27] rdata_asic[27] vdd
+ vdd_array vss vss / asic_io_p2
Xasic_io_rwdl_0<26> rwdl_array[26] out_en[1] wdata_ff[26] rdata_asic[26] vdd
+ vdd_array vss vss / asic_io_p2
Xasic_io_rwdl_0<25> rwdl_array[25] out_en[1] wdata_ff[25] rdata_asic[25] vdd
+ vdd_array vss vss / asic_io_p2
Xasic_io_rwdl_0<24> rwdl_array[24] out_en[1] wdata_ff[24] rdata_asic[24] vdd
+ vdd_array vss vss / asic_io_p2
Xasic_io_rwdl_0<23> rwdl_array[23] out_en[1] wdata_ff[23] rdata_asic[23] vdd
+ vdd_array vss vss / asic_io_p2
Xasic_io_rwdl_0<22> rwdl_array[22] out_en[1] wdata_ff[22] rdata_asic[22] vdd
+ vdd_array vss vss / asic_io_p2
Xasic_io_rwdl_0<21> rwdl_array[21] out_en[1] wdata_ff[21] rdata_asic[21] vdd
+ vdd_array vss vss / asic_io_p2
Xasic_io_rwdl_0<20> rwdl_array[20] out_en[1] wdata_ff[20] rdata_asic[20] vdd
+ vdd_array vss vss / asic_io_p2
Xasic_io_rwdl_0<19> rwdl_array[19] out_en[1] wdata_ff[19] rdata_asic[19] vdd
+ vdd_array vss vss / asic_io_p2
Xasic_io_rwdl_0<18> rwdl_array[18] out_en[1] wdata_ff[18] rdata_asic[18] vdd
+ vdd_array vss vss / asic_io_p2
Xasic_io_rwdl_0<17> rwdl_array[17] out_en[1] wdata_ff[17] rdata_asic[17] vdd
+ vdd_array vss vss / asic_io_p2
Xasic_io_rwdl_0<16> rwdl_array[16] out_en[1] wdata_ff[16] rdata_asic[16] vdd
+ vdd_array vss vss / asic_io_p2
Xasic_io_rwdl_0<15> rwdl_array[15] out_en[1] wdata_ff[15] rdata_asic[15] vdd
+ vdd_array vss vss / asic_io_p2
Xasic_io_rwdl_0<14> rwdl_array[14] out_en[1] wdata_ff[14] rdata_asic[14] vdd
+ vdd_array vss vss / asic_io_p2
Xasic_io_rwdl_0<13> rwdl_array[13] out_en[1] wdata_ff[13] rdata_asic[13] vdd
+ vdd_array vss vss / asic_io_p2
Xasic_io_rwdl_0<12> rwdl_array[12] out_en[1] wdata_ff[12] rdata_asic[12] vdd
+ vdd_array vss vss / asic_io_p2
Xasic_io_rwdl_0<11> rwdl_array[11] out_en[1] wdata_ff[11] rdata_asic[11] vdd
+ vdd_array vss vss / asic_io_p2
Xasic_io_rwdl_0<10> rwdl_array[10] out_en[1] wdata_ff[10] rdata_asic[10] vdd
+ vdd_array vss vss / asic_io_p2
Xasic_io_rwdl_0<9> rwdl_array[9] out_en[1] wdata_ff[9] rdata_asic[9] vdd
+ vdd_array vss vss / asic_io_p2
Xasic_io_rwdl_0<8> rwdl_array[8] out_en[1] wdata_ff[8] rdata_asic[8] vdd
+ vdd_array vss vss / asic_io_p2
Xasic_io_rwdl_0<7> rwdl_array[7] out_en[1] wdata_ff[7] rdata_asic[7] vdd
+ vdd_array vss vss / asic_io_p2
Xasic_io_rwdl_0<6> rwdl_array[6] out_en[1] wdata_ff[6] rdata_asic[6] vdd
+ vdd_array vss vss / asic_io_p2
Xasic_io_rwdl_0<5> rwdl_array[5] out_en[1] wdata_ff[5] rdata_asic[5] vdd
+ vdd_array vss vss / asic_io_p2
Xasic_io_rwdl_0<4> rwdl_array[4] out_en[1] wdata_ff[4] rdata_asic[4] vdd
+ vdd_array vss vss / asic_io_p2
Xasic_io_rwdl_0<3> rwdl_array[3] out_en[1] wdata_ff[3] rdata_asic[3] vdd
+ vdd_array vss vss / asic_io_p2
Xasic_io_rwdl_0<2> rwdl_array[2] out_en[1] wdata_ff[2] rdata_asic[2] vdd
+ vdd_array vss vss / asic_io_p2
Xasic_io_rwdl_0<1> rwdl_array[1] out_en[1] wdata_ff[1] rdata_asic[1] vdd
+ vdd_array vss vss / asic_io_p2
Xasic_io_rwdl_0<0> rwdl_array[0] out_en[1] wdata_ff[0] rdata_asic[0] vdd
+ vdd_array vss vss / asic_io_p2
Xasic_io_rwdl_1<135> rwdl_array[271] out_en[0] wdata_ff[271] rdata_asic[271]
+ vdd vdd_array vss vss / asic_io_p2
Xasic_io_rwdl_1<134> rwdl_array[270] out_en[0] wdata_ff[270] rdata_asic[270]
+ vdd vdd_array vss vss / asic_io_p2
Xasic_io_rwdl_1<133> rwdl_array[269] out_en[0] wdata_ff[269] rdata_asic[269]
+ vdd vdd_array vss vss / asic_io_p2
Xasic_io_rwdl_1<132> rwdl_array[268] out_en[0] wdata_ff[268] rdata_asic[268]
+ vdd vdd_array vss vss / asic_io_p2
Xasic_io_rwdl_1<131> rwdl_array[267] out_en[0] wdata_ff[267] rdata_asic[267]
+ vdd vdd_array vss vss / asic_io_p2
Xasic_io_rwdl_1<130> rwdl_array[266] out_en[0] wdata_ff[266] rdata_asic[266]
+ vdd vdd_array vss vss / asic_io_p2
Xasic_io_rwdl_1<129> rwdl_array[265] out_en[0] wdata_ff[265] rdata_asic[265]
+ vdd vdd_array vss vss / asic_io_p2
Xasic_io_rwdl_1<128> rwdl_array[264] out_en[0] wdata_ff[264] rdata_asic[264]
+ vdd vdd_array vss vss / asic_io_p2
Xasic_io_rwdl_1<127> rwdl_array[263] out_en[0] wdata_ff[263] rdata_asic[263]
+ vdd vdd_array vss vss / asic_io_p2
Xasic_io_rwdl_1<126> rwdl_array[262] out_en[0] wdata_ff[262] rdata_asic[262]
+ vdd vdd_array vss vss / asic_io_p2
Xasic_io_rwdl_1<125> rwdl_array[261] out_en[0] wdata_ff[261] rdata_asic[261]
+ vdd vdd_array vss vss / asic_io_p2
Xasic_io_rwdl_1<124> rwdl_array[260] out_en[0] wdata_ff[260] rdata_asic[260]
+ vdd vdd_array vss vss / asic_io_p2
Xasic_io_rwdl_1<123> rwdl_array[259] out_en[0] wdata_ff[259] rdata_asic[259]
+ vdd vdd_array vss vss / asic_io_p2
Xasic_io_rwdl_1<122> rwdl_array[258] out_en[0] wdata_ff[258] rdata_asic[258]
+ vdd vdd_array vss vss / asic_io_p2
Xasic_io_rwdl_1<121> rwdl_array[257] out_en[0] wdata_ff[257] rdata_asic[257]
+ vdd vdd_array vss vss / asic_io_p2
Xasic_io_rwdl_1<120> rwdl_array[256] out_en[0] wdata_ff[256] rdata_asic[256]
+ vdd vdd_array vss vss / asic_io_p2
Xasic_io_rwdl_1<119> rwdl_array[255] out_en[0] wdata_ff[255] rdata_asic[255]
+ vdd vdd_array vss vss / asic_io_p2
Xasic_io_rwdl_1<118> rwdl_array[254] out_en[0] wdata_ff[254] rdata_asic[254]
+ vdd vdd_array vss vss / asic_io_p2
Xasic_io_rwdl_1<117> rwdl_array[253] out_en[0] wdata_ff[253] rdata_asic[253]
+ vdd vdd_array vss vss / asic_io_p2
Xasic_io_rwdl_1<116> rwdl_array[252] out_en[0] wdata_ff[252] rdata_asic[252]
+ vdd vdd_array vss vss / asic_io_p2
Xasic_io_rwdl_1<115> rwdl_array[251] out_en[0] wdata_ff[251] rdata_asic[251]
+ vdd vdd_array vss vss / asic_io_p2
Xasic_io_rwdl_1<114> rwdl_array[250] out_en[0] wdata_ff[250] rdata_asic[250]
+ vdd vdd_array vss vss / asic_io_p2
Xasic_io_rwdl_1<113> rwdl_array[249] out_en[0] wdata_ff[249] rdata_asic[249]
+ vdd vdd_array vss vss / asic_io_p2
Xasic_io_rwdl_1<112> rwdl_array[248] out_en[0] wdata_ff[248] rdata_asic[248]
+ vdd vdd_array vss vss / asic_io_p2
Xasic_io_rwdl_1<111> rwdl_array[247] out_en[0] wdata_ff[247] rdata_asic[247]
+ vdd vdd_array vss vss / asic_io_p2
Xasic_io_rwdl_1<110> rwdl_array[246] out_en[0] wdata_ff[246] rdata_asic[246]
+ vdd vdd_array vss vss / asic_io_p2
Xasic_io_rwdl_1<109> rwdl_array[245] out_en[0] wdata_ff[245] rdata_asic[245]
+ vdd vdd_array vss vss / asic_io_p2
Xasic_io_rwdl_1<108> rwdl_array[244] out_en[0] wdata_ff[244] rdata_asic[244]
+ vdd vdd_array vss vss / asic_io_p2
Xasic_io_rwdl_1<107> rwdl_array[243] out_en[0] wdata_ff[243] rdata_asic[243]
+ vdd vdd_array vss vss / asic_io_p2
Xasic_io_rwdl_1<106> rwdl_array[242] out_en[0] wdata_ff[242] rdata_asic[242]
+ vdd vdd_array vss vss / asic_io_p2
Xasic_io_rwdl_1<105> rwdl_array[241] out_en[0] wdata_ff[241] rdata_asic[241]
+ vdd vdd_array vss vss / asic_io_p2
Xasic_io_rwdl_1<104> rwdl_array[240] out_en[0] wdata_ff[240] rdata_asic[240]
+ vdd vdd_array vss vss / asic_io_p2
Xasic_io_rwdl_1<103> rwdl_array[239] out_en[0] wdata_ff[239] rdata_asic[239]
+ vdd vdd_array vss vss / asic_io_p2
Xasic_io_rwdl_1<102> rwdl_array[238] out_en[0] wdata_ff[238] rdata_asic[238]
+ vdd vdd_array vss vss / asic_io_p2
Xasic_io_rwdl_1<101> rwdl_array[237] out_en[0] wdata_ff[237] rdata_asic[237]
+ vdd vdd_array vss vss / asic_io_p2
Xasic_io_rwdl_1<100> rwdl_array[236] out_en[0] wdata_ff[236] rdata_asic[236]
+ vdd vdd_array vss vss / asic_io_p2
Xasic_io_rwdl_1<99> rwdl_array[235] out_en[0] wdata_ff[235] rdata_asic[235]
+ vdd vdd_array vss vss / asic_io_p2
Xasic_io_rwdl_1<98> rwdl_array[234] out_en[0] wdata_ff[234] rdata_asic[234]
+ vdd vdd_array vss vss / asic_io_p2
Xasic_io_rwdl_1<97> rwdl_array[233] out_en[0] wdata_ff[233] rdata_asic[233]
+ vdd vdd_array vss vss / asic_io_p2
Xasic_io_rwdl_1<96> rwdl_array[232] out_en[0] wdata_ff[232] rdata_asic[232]
+ vdd vdd_array vss vss / asic_io_p2
Xasic_io_rwdl_1<95> rwdl_array[231] out_en[0] wdata_ff[231] rdata_asic[231]
+ vdd vdd_array vss vss / asic_io_p2
Xasic_io_rwdl_1<94> rwdl_array[230] out_en[0] wdata_ff[230] rdata_asic[230]
+ vdd vdd_array vss vss / asic_io_p2
Xasic_io_rwdl_1<93> rwdl_array[229] out_en[0] wdata_ff[229] rdata_asic[229]
+ vdd vdd_array vss vss / asic_io_p2
Xasic_io_rwdl_1<92> rwdl_array[228] out_en[0] wdata_ff[228] rdata_asic[228]
+ vdd vdd_array vss vss / asic_io_p2
Xasic_io_rwdl_1<91> rwdl_array[227] out_en[0] wdata_ff[227] rdata_asic[227]
+ vdd vdd_array vss vss / asic_io_p2
Xasic_io_rwdl_1<90> rwdl_array[226] out_en[0] wdata_ff[226] rdata_asic[226]
+ vdd vdd_array vss vss / asic_io_p2
Xasic_io_rwdl_1<89> rwdl_array[225] out_en[0] wdata_ff[225] rdata_asic[225]
+ vdd vdd_array vss vss / asic_io_p2
Xasic_io_rwdl_1<88> rwdl_array[224] out_en[0] wdata_ff[224] rdata_asic[224]
+ vdd vdd_array vss vss / asic_io_p2
Xasic_io_rwdl_1<87> rwdl_array[223] out_en[0] wdata_ff[223] rdata_asic[223]
+ vdd vdd_array vss vss / asic_io_p2
Xasic_io_rwdl_1<86> rwdl_array[222] out_en[0] wdata_ff[222] rdata_asic[222]
+ vdd vdd_array vss vss / asic_io_p2
Xasic_io_rwdl_1<85> rwdl_array[221] out_en[0] wdata_ff[221] rdata_asic[221]
+ vdd vdd_array vss vss / asic_io_p2
Xasic_io_rwdl_1<84> rwdl_array[220] out_en[0] wdata_ff[220] rdata_asic[220]
+ vdd vdd_array vss vss / asic_io_p2
Xasic_io_rwdl_1<83> rwdl_array[219] out_en[0] wdata_ff[219] rdata_asic[219]
+ vdd vdd_array vss vss / asic_io_p2
Xasic_io_rwdl_1<82> rwdl_array[218] out_en[0] wdata_ff[218] rdata_asic[218]
+ vdd vdd_array vss vss / asic_io_p2
Xasic_io_rwdl_1<81> rwdl_array[217] out_en[0] wdata_ff[217] rdata_asic[217]
+ vdd vdd_array vss vss / asic_io_p2
Xasic_io_rwdl_1<80> rwdl_array[216] out_en[0] wdata_ff[216] rdata_asic[216]
+ vdd vdd_array vss vss / asic_io_p2
Xasic_io_rwdl_1<79> rwdl_array[215] out_en[0] wdata_ff[215] rdata_asic[215]
+ vdd vdd_array vss vss / asic_io_p2
Xasic_io_rwdl_1<78> rwdl_array[214] out_en[0] wdata_ff[214] rdata_asic[214]
+ vdd vdd_array vss vss / asic_io_p2
Xasic_io_rwdl_1<77> rwdl_array[213] out_en[0] wdata_ff[213] rdata_asic[213]
+ vdd vdd_array vss vss / asic_io_p2
Xasic_io_rwdl_1<76> rwdl_array[212] out_en[0] wdata_ff[212] rdata_asic[212]
+ vdd vdd_array vss vss / asic_io_p2
Xasic_io_rwdl_1<75> rwdl_array[211] out_en[0] wdata_ff[211] rdata_asic[211]
+ vdd vdd_array vss vss / asic_io_p2
Xasic_io_rwdl_1<74> rwdl_array[210] out_en[0] wdata_ff[210] rdata_asic[210]
+ vdd vdd_array vss vss / asic_io_p2
Xasic_io_rwdl_1<73> rwdl_array[209] out_en[0] wdata_ff[209] rdata_asic[209]
+ vdd vdd_array vss vss / asic_io_p2
Xasic_io_rwdl_1<72> rwdl_array[208] out_en[0] wdata_ff[208] rdata_asic[208]
+ vdd vdd_array vss vss / asic_io_p2
Xasic_io_rwdl_1<71> rwdl_array[207] out_en[0] wdata_ff[207] rdata_asic[207]
+ vdd vdd_array vss vss / asic_io_p2
Xasic_io_rwdl_1<70> rwdl_array[206] out_en[0] wdata_ff[206] rdata_asic[206]
+ vdd vdd_array vss vss / asic_io_p2
Xasic_io_rwdl_1<69> rwdl_array[205] out_en[0] wdata_ff[205] rdata_asic[205]
+ vdd vdd_array vss vss / asic_io_p2
Xasic_io_rwdl_1<68> rwdl_array[204] out_en[0] wdata_ff[204] rdata_asic[204]
+ vdd vdd_array vss vss / asic_io_p2
Xasic_io_rwdl_1<67> rwdl_array[203] out_en[0] wdata_ff[203] rdata_asic[203]
+ vdd vdd_array vss vss / asic_io_p2
Xasic_io_rwdl_1<66> rwdl_array[202] out_en[0] wdata_ff[202] rdata_asic[202]
+ vdd vdd_array vss vss / asic_io_p2
Xasic_io_rwdl_1<65> rwdl_array[201] out_en[0] wdata_ff[201] rdata_asic[201]
+ vdd vdd_array vss vss / asic_io_p2
Xasic_io_rwdl_1<64> rwdl_array[200] out_en[0] wdata_ff[200] rdata_asic[200]
+ vdd vdd_array vss vss / asic_io_p2
Xasic_io_rwdl_1<63> rwdl_array[199] out_en[0] wdata_ff[199] rdata_asic[199]
+ vdd vdd_array vss vss / asic_io_p2
Xasic_io_rwdl_1<62> rwdl_array[198] out_en[0] wdata_ff[198] rdata_asic[198]
+ vdd vdd_array vss vss / asic_io_p2
Xasic_io_rwdl_1<61> rwdl_array[197] out_en[0] wdata_ff[197] rdata_asic[197]
+ vdd vdd_array vss vss / asic_io_p2
Xasic_io_rwdl_1<60> rwdl_array[196] out_en[0] wdata_ff[196] rdata_asic[196]
+ vdd vdd_array vss vss / asic_io_p2
Xasic_io_rwdl_1<59> rwdl_array[195] out_en[0] wdata_ff[195] rdata_asic[195]
+ vdd vdd_array vss vss / asic_io_p2
Xasic_io_rwdl_1<58> rwdl_array[194] out_en[0] wdata_ff[194] rdata_asic[194]
+ vdd vdd_array vss vss / asic_io_p2
Xasic_io_rwdl_1<57> rwdl_array[193] out_en[0] wdata_ff[193] rdata_asic[193]
+ vdd vdd_array vss vss / asic_io_p2
Xasic_io_rwdl_1<56> rwdl_array[192] out_en[0] wdata_ff[192] rdata_asic[192]
+ vdd vdd_array vss vss / asic_io_p2
Xasic_io_rwdl_1<55> rwdl_array[191] out_en[0] wdata_ff[191] rdata_asic[191]
+ vdd vdd_array vss vss / asic_io_p2
Xasic_io_rwdl_1<54> rwdl_array[190] out_en[0] wdata_ff[190] rdata_asic[190]
+ vdd vdd_array vss vss / asic_io_p2
Xasic_io_rwdl_1<53> rwdl_array[189] out_en[0] wdata_ff[189] rdata_asic[189]
+ vdd vdd_array vss vss / asic_io_p2
Xasic_io_rwdl_1<52> rwdl_array[188] out_en[0] wdata_ff[188] rdata_asic[188]
+ vdd vdd_array vss vss / asic_io_p2
Xasic_io_rwdl_1<51> rwdl_array[187] out_en[0] wdata_ff[187] rdata_asic[187]
+ vdd vdd_array vss vss / asic_io_p2
Xasic_io_rwdl_1<50> rwdl_array[186] out_en[0] wdata_ff[186] rdata_asic[186]
+ vdd vdd_array vss vss / asic_io_p2
Xasic_io_rwdl_1<49> rwdl_array[185] out_en[0] wdata_ff[185] rdata_asic[185]
+ vdd vdd_array vss vss / asic_io_p2
Xasic_io_rwdl_1<48> rwdl_array[184] out_en[0] wdata_ff[184] rdata_asic[184]
+ vdd vdd_array vss vss / asic_io_p2
Xasic_io_rwdl_1<47> rwdl_array[183] out_en[0] wdata_ff[183] rdata_asic[183]
+ vdd vdd_array vss vss / asic_io_p2
Xasic_io_rwdl_1<46> rwdl_array[182] out_en[0] wdata_ff[182] rdata_asic[182]
+ vdd vdd_array vss vss / asic_io_p2
Xasic_io_rwdl_1<45> rwdl_array[181] out_en[0] wdata_ff[181] rdata_asic[181]
+ vdd vdd_array vss vss / asic_io_p2
Xasic_io_rwdl_1<44> rwdl_array[180] out_en[0] wdata_ff[180] rdata_asic[180]
+ vdd vdd_array vss vss / asic_io_p2
Xasic_io_rwdl_1<43> rwdl_array[179] out_en[0] wdata_ff[179] rdata_asic[179]
+ vdd vdd_array vss vss / asic_io_p2
Xasic_io_rwdl_1<42> rwdl_array[178] out_en[0] wdata_ff[178] rdata_asic[178]
+ vdd vdd_array vss vss / asic_io_p2
Xasic_io_rwdl_1<41> rwdl_array[177] out_en[0] wdata_ff[177] rdata_asic[177]
+ vdd vdd_array vss vss / asic_io_p2
Xasic_io_rwdl_1<40> rwdl_array[176] out_en[0] wdata_ff[176] rdata_asic[176]
+ vdd vdd_array vss vss / asic_io_p2
Xasic_io_rwdl_1<39> rwdl_array[175] out_en[0] wdata_ff[175] rdata_asic[175]
+ vdd vdd_array vss vss / asic_io_p2
Xasic_io_rwdl_1<38> rwdl_array[174] out_en[0] wdata_ff[174] rdata_asic[174]
+ vdd vdd_array vss vss / asic_io_p2
Xasic_io_rwdl_1<37> rwdl_array[173] out_en[0] wdata_ff[173] rdata_asic[173]
+ vdd vdd_array vss vss / asic_io_p2
Xasic_io_rwdl_1<36> rwdl_array[172] out_en[0] wdata_ff[172] rdata_asic[172]
+ vdd vdd_array vss vss / asic_io_p2
Xasic_io_rwdl_1<35> rwdl_array[171] out_en[0] wdata_ff[171] rdata_asic[171]
+ vdd vdd_array vss vss / asic_io_p2
Xasic_io_rwdl_1<34> rwdl_array[170] out_en[0] wdata_ff[170] rdata_asic[170]
+ vdd vdd_array vss vss / asic_io_p2
Xasic_io_rwdl_1<33> rwdl_array[169] out_en[0] wdata_ff[169] rdata_asic[169]
+ vdd vdd_array vss vss / asic_io_p2
Xasic_io_rwdl_1<32> rwdl_array[168] out_en[0] wdata_ff[168] rdata_asic[168]
+ vdd vdd_array vss vss / asic_io_p2
Xasic_io_rwdl_1<31> rwdl_array[167] out_en[0] wdata_ff[167] rdata_asic[167]
+ vdd vdd_array vss vss / asic_io_p2
Xasic_io_rwdl_1<30> rwdl_array[166] out_en[0] wdata_ff[166] rdata_asic[166]
+ vdd vdd_array vss vss / asic_io_p2
Xasic_io_rwdl_1<29> rwdl_array[165] out_en[0] wdata_ff[165] rdata_asic[165]
+ vdd vdd_array vss vss / asic_io_p2
Xasic_io_rwdl_1<28> rwdl_array[164] out_en[0] wdata_ff[164] rdata_asic[164]
+ vdd vdd_array vss vss / asic_io_p2
Xasic_io_rwdl_1<27> rwdl_array[163] out_en[0] wdata_ff[163] rdata_asic[163]
+ vdd vdd_array vss vss / asic_io_p2
Xasic_io_rwdl_1<26> rwdl_array[162] out_en[0] wdata_ff[162] rdata_asic[162]
+ vdd vdd_array vss vss / asic_io_p2
Xasic_io_rwdl_1<25> rwdl_array[161] out_en[0] wdata_ff[161] rdata_asic[161]
+ vdd vdd_array vss vss / asic_io_p2
Xasic_io_rwdl_1<24> rwdl_array[160] out_en[0] wdata_ff[160] rdata_asic[160]
+ vdd vdd_array vss vss / asic_io_p2
Xasic_io_rwdl_1<23> rwdl_array[159] out_en[0] wdata_ff[159] rdata_asic[159]
+ vdd vdd_array vss vss / asic_io_p2
Xasic_io_rwdl_1<22> rwdl_array[158] out_en[0] wdata_ff[158] rdata_asic[158]
+ vdd vdd_array vss vss / asic_io_p2
Xasic_io_rwdl_1<21> rwdl_array[157] out_en[0] wdata_ff[157] rdata_asic[157]
+ vdd vdd_array vss vss / asic_io_p2
Xasic_io_rwdl_1<20> rwdl_array[156] out_en[0] wdata_ff[156] rdata_asic[156]
+ vdd vdd_array vss vss / asic_io_p2
Xasic_io_rwdl_1<19> rwdl_array[155] out_en[0] wdata_ff[155] rdata_asic[155]
+ vdd vdd_array vss vss / asic_io_p2
Xasic_io_rwdl_1<18> rwdl_array[154] out_en[0] wdata_ff[154] rdata_asic[154]
+ vdd vdd_array vss vss / asic_io_p2
Xasic_io_rwdl_1<17> rwdl_array[153] out_en[0] wdata_ff[153] rdata_asic[153]
+ vdd vdd_array vss vss / asic_io_p2
Xasic_io_rwdl_1<16> rwdl_array[152] out_en[0] wdata_ff[152] rdata_asic[152]
+ vdd vdd_array vss vss / asic_io_p2
Xasic_io_rwdl_1<15> rwdl_array[151] out_en[0] wdata_ff[151] rdata_asic[151]
+ vdd vdd_array vss vss / asic_io_p2
Xasic_io_rwdl_1<14> rwdl_array[150] out_en[0] wdata_ff[150] rdata_asic[150]
+ vdd vdd_array vss vss / asic_io_p2
Xasic_io_rwdl_1<13> rwdl_array[149] out_en[0] wdata_ff[149] rdata_asic[149]
+ vdd vdd_array vss vss / asic_io_p2
Xasic_io_rwdl_1<12> rwdl_array[148] out_en[0] wdata_ff[148] rdata_asic[148]
+ vdd vdd_array vss vss / asic_io_p2
Xasic_io_rwdl_1<11> rwdl_array[147] out_en[0] wdata_ff[147] rdata_asic[147]
+ vdd vdd_array vss vss / asic_io_p2
Xasic_io_rwdl_1<10> rwdl_array[146] out_en[0] wdata_ff[146] rdata_asic[146]
+ vdd vdd_array vss vss / asic_io_p2
Xasic_io_rwdl_1<9> rwdl_array[145] out_en[0] wdata_ff[145] rdata_asic[145] vdd
+ vdd_array vss vss / asic_io_p2
Xasic_io_rwdl_1<8> rwdl_array[144] out_en[0] wdata_ff[144] rdata_asic[144] vdd
+ vdd_array vss vss / asic_io_p2
Xasic_io_rwdl_1<7> rwdl_array[143] out_en[0] wdata_ff[143] rdata_asic[143] vdd
+ vdd_array vss vss / asic_io_p2
Xasic_io_rwdl_1<6> rwdl_array[142] out_en[0] wdata_ff[142] rdata_asic[142] vdd
+ vdd_array vss vss / asic_io_p2
Xasic_io_rwdl_1<5> rwdl_array[141] out_en[0] wdata_ff[141] rdata_asic[141] vdd
+ vdd_array vss vss / asic_io_p2
Xasic_io_rwdl_1<4> rwdl_array[140] out_en[0] wdata_ff[140] rdata_asic[140] vdd
+ vdd_array vss vss / asic_io_p2
Xasic_io_rwdl_1<3> rwdl_array[139] out_en[0] wdata_ff[139] rdata_asic[139] vdd
+ vdd_array vss vss / asic_io_p2
Xasic_io_rwdl_1<2> rwdl_array[138] out_en[0] wdata_ff[138] rdata_asic[138] vdd
+ vdd_array vss vss / asic_io_p2
Xasic_io_rwdl_1<1> rwdl_array[137] out_en[0] wdata_ff[137] rdata_asic[137] vdd
+ vdd_array vss vss / asic_io_p2
Xasic_io_rwdl_1<0> rwdl_array[136] out_en[0] wdata_ff[136] rdata_asic[136] vdd
+ vdd_array vss vss / asic_io_p2
Xi369 gcas_wr_ff_0 vdd vss net55 / BUFFD2BWP7T30P140
Xi368 net55 vdd vss net54 / BUFFD2BWP7T30P140
Xi367 net54 vdd vss net52 / BUFFD2BWP7T30P140
Xi366 net52 vdd vss net53 / BUFFD2BWP7T30P140
Xi365 net50 vdd vss net51 / BUFFD2BWP7T30P140
Xi364 net49 vdd vss net50 / BUFFD2BWP7T30P140
Xi363 net48 vdd vss net49 / BUFFD2BWP7T30P140
Xi346 net45 vdd vss net47 / BUFFD2BWP7T30P140
Xi347 net45 vdd vss net35 / BUFFD2BWP7T30P140
Xi349 net51 vdd vss gcas_wr_ff_buf_1 / BUFFD2BWP7T30P140
Xi261 net53 vdd vss gcas_wr_ff_buf_0 / BUFFD2BWP7T30P140
Xi332 net18 vdd vss net19 / BUFFD2BWP7T30P140
Xi331 net19 vdd vss net17 / BUFFD2BWP7T30P140
Xi361 gcas_wr_ff_1 vdd vss net48 / BUFFD2BWP7T30P140
Xi276 net0252 vdd vss net0183 / BUFFD2BWP7T30P140
Xi270 bnksel_n_d0_ff_0 vdd vss net0127 / BUFFD2BWP7T30P140
Xi277 net0183 vdd vss gcas_rd_ff_buf_0 / BUFFD2BWP7T30P140
Xi233 net1 vdd vss net491 / BUFFD2BWP7T30P140
Xi235 net393 vdd vss clk_gcas_wr / BUFFD2BWP7T30P140
Xi236 net393 vdd vss clk_gcas_rd / BUFFD2BWP7T30P140
Xi271 net0151 vdd vss net0615 / BUFFD2BWP7T30P140
Xi272 net0615 vdd vss net0614 / BUFFD2BWP7T30P140
Xi333 gcas_rd_ff_1 vdd vss net22 / BUFFD2BWP7T30P140
Xi330 bnksel_n_d0_ff_1 vdd vss net3 / BUFFD2BWP7T30P140
Xi336 net22 vdd vss net34 / BUFFD2BWP7T30P140
Xi335 net34 vdd vss gcas_rd_ff_buf_1 / BUFFD2BWP7T30P140
Xi266 gcas_rd_ff_0 vdd vss net0252 / BUFFD2BWP7T30P140
Xasic_in_rdrdy_n net8 ls_en_drv4[0] rdrdy_n_asic tiehi_1 ls_en_drv4[0] vdd
+ vdd_array vss vss / asic_in
Xi362<31> net499 vdd vss out_en[1] / BUFFD8BWP7T30P140
Xi362<30> net499 vdd vss out_en[1] / BUFFD8BWP7T30P140
Xi362<29> net499 vdd vss out_en[1] / BUFFD8BWP7T30P140
Xi362<28> net499 vdd vss out_en[1] / BUFFD8BWP7T30P140
Xi362<27> net499 vdd vss out_en[1] / BUFFD8BWP7T30P140
Xi362<26> net499 vdd vss out_en[1] / BUFFD8BWP7T30P140
Xi362<25> net499 vdd vss out_en[1] / BUFFD8BWP7T30P140
Xi362<24> net499 vdd vss out_en[1] / BUFFD8BWP7T30P140
Xi362<23> net499 vdd vss out_en[1] / BUFFD8BWP7T30P140
Xi362<22> net499 vdd vss out_en[1] / BUFFD8BWP7T30P140
Xi362<21> net499 vdd vss out_en[1] / BUFFD8BWP7T30P140
Xi362<20> net499 vdd vss out_en[1] / BUFFD8BWP7T30P140
Xi362<19> net499 vdd vss out_en[1] / BUFFD8BWP7T30P140
Xi362<18> net499 vdd vss out_en[1] / BUFFD8BWP7T30P140
Xi362<17> net499 vdd vss out_en[1] / BUFFD8BWP7T30P140
Xi362<16> net499 vdd vss out_en[1] / BUFFD8BWP7T30P140
Xi362<15> net499 vdd vss out_en[1] / BUFFD8BWP7T30P140
Xi362<14> net499 vdd vss out_en[1] / BUFFD8BWP7T30P140
Xi362<13> net499 vdd vss out_en[1] / BUFFD8BWP7T30P140
Xi362<12> net499 vdd vss out_en[1] / BUFFD8BWP7T30P140
Xi362<11> net499 vdd vss out_en[1] / BUFFD8BWP7T30P140
Xi362<10> net499 vdd vss out_en[1] / BUFFD8BWP7T30P140
Xi362<9> net499 vdd vss out_en[1] / BUFFD8BWP7T30P140
Xi362<8> net499 vdd vss out_en[1] / BUFFD8BWP7T30P140
Xi362<7> net499 vdd vss out_en[1] / BUFFD8BWP7T30P140
Xi362<6> net499 vdd vss out_en[1] / BUFFD8BWP7T30P140
Xi362<5> net499 vdd vss out_en[1] / BUFFD8BWP7T30P140
Xi362<4> net499 vdd vss out_en[1] / BUFFD8BWP7T30P140
Xi362<3> net499 vdd vss out_en[1] / BUFFD8BWP7T30P140
Xi362<2> net499 vdd vss out_en[1] / BUFFD8BWP7T30P140
Xi362<1> net499 vdd vss out_en[1] / BUFFD8BWP7T30P140
Xi362<0> net499 vdd vss out_en[1] / BUFFD8BWP7T30P140
Xi360<31> net499 vdd vss out_en[0] / BUFFD8BWP7T30P140
Xi360<30> net499 vdd vss out_en[0] / BUFFD8BWP7T30P140
Xi360<29> net499 vdd vss out_en[0] / BUFFD8BWP7T30P140
Xi360<28> net499 vdd vss out_en[0] / BUFFD8BWP7T30P140
Xi360<27> net499 vdd vss out_en[0] / BUFFD8BWP7T30P140
Xi360<26> net499 vdd vss out_en[0] / BUFFD8BWP7T30P140
Xi360<25> net499 vdd vss out_en[0] / BUFFD8BWP7T30P140
Xi360<24> net499 vdd vss out_en[0] / BUFFD8BWP7T30P140
Xi360<23> net499 vdd vss out_en[0] / BUFFD8BWP7T30P140
Xi360<22> net499 vdd vss out_en[0] / BUFFD8BWP7T30P140
Xi360<21> net499 vdd vss out_en[0] / BUFFD8BWP7T30P140
Xi360<20> net499 vdd vss out_en[0] / BUFFD8BWP7T30P140
Xi360<19> net499 vdd vss out_en[0] / BUFFD8BWP7T30P140
Xi360<18> net499 vdd vss out_en[0] / BUFFD8BWP7T30P140
Xi360<17> net499 vdd vss out_en[0] / BUFFD8BWP7T30P140
Xi360<16> net499 vdd vss out_en[0] / BUFFD8BWP7T30P140
Xi360<15> net499 vdd vss out_en[0] / BUFFD8BWP7T30P140
Xi360<14> net499 vdd vss out_en[0] / BUFFD8BWP7T30P140
Xi360<13> net499 vdd vss out_en[0] / BUFFD8BWP7T30P140
Xi360<12> net499 vdd vss out_en[0] / BUFFD8BWP7T30P140
Xi360<11> net499 vdd vss out_en[0] / BUFFD8BWP7T30P140
Xi360<10> net499 vdd vss out_en[0] / BUFFD8BWP7T30P140
Xi360<9> net499 vdd vss out_en[0] / BUFFD8BWP7T30P140
Xi360<8> net499 vdd vss out_en[0] / BUFFD8BWP7T30P140
Xi360<7> net499 vdd vss out_en[0] / BUFFD8BWP7T30P140
Xi360<6> net499 vdd vss out_en[0] / BUFFD8BWP7T30P140
Xi360<5> net499 vdd vss out_en[0] / BUFFD8BWP7T30P140
Xi360<4> net499 vdd vss out_en[0] / BUFFD8BWP7T30P140
Xi360<3> net499 vdd vss out_en[0] / BUFFD8BWP7T30P140
Xi360<2> net499 vdd vss out_en[0] / BUFFD8BWP7T30P140
Xi360<1> net499 vdd vss out_en[0] / BUFFD8BWP7T30P140
Xi360<0> net499 vdd vss out_en[0] / BUFFD8BWP7T30P140
Xi247<3> ls_en_drv3 vdd vss ls_en_drv4[1] / BUFFD8BWP7T30P140
Xi247<2> ls_en_drv3 vdd vss ls_en_drv4[1] / BUFFD8BWP7T30P140
Xi247<1> ls_en_drv3 vdd vss ls_en_drv4[1] / BUFFD8BWP7T30P140
Xi247<0> ls_en_drv3 vdd vss ls_en_drv4[1] / BUFFD8BWP7T30P140
Xi248<3> ls_en_drv3 vdd vss ls_en_drv4[0] / BUFFD8BWP7T30P140
Xi248<2> ls_en_drv3 vdd vss ls_en_drv4[0] / BUFFD8BWP7T30P140
Xi248<1> ls_en_drv3 vdd vss ls_en_drv4[0] / BUFFD8BWP7T30P140
Xi248<0> ls_en_drv3 vdd vss ls_en_drv4[0] / BUFFD8BWP7T30P140
Xi246<3> ls_en_drv3 vdd vss ls_en_drv4[2] / BUFFD8BWP7T30P140
Xi246<2> ls_en_drv3 vdd vss ls_en_drv4[2] / BUFFD8BWP7T30P140
Xi246<1> ls_en_drv3 vdd vss ls_en_drv4[2] / BUFFD8BWP7T30P140
Xi246<0> ls_en_drv3 vdd vss ls_en_drv4[2] / BUFFD8BWP7T30P140
Xi224 net387 vdd vss clk9 / BUFFD8BWP7T30P140
Xi223 net387 vdd vss clk8 / BUFFD8BWP7T30P140
Xi221 net387 vdd vss clk11 / BUFFD8BWP7T30P140
Xi222 net387 vdd vss clk10 / BUFFD8BWP7T30P140
Xi229 net387 vdd vss clk0 / BUFFD8BWP7T30P140
Xi228 net387 vdd vss clk1 / BUFFD8BWP7T30P140
Xi230 net387 vdd vss clk2 / BUFFD8BWP7T30P140
Xi227 net387 vdd vss clk3 / BUFFD8BWP7T30P140
Xi245<3> ls_en_drv3 vdd vss ls_en_drv4[3] / BUFFD8BWP7T30P140
Xi245<2> ls_en_drv3 vdd vss ls_en_drv4[3] / BUFFD8BWP7T30P140
Xi245<1> ls_en_drv3 vdd vss ls_en_drv4[3] / BUFFD8BWP7T30P140
Xi245<0> ls_en_drv3 vdd vss ls_en_drv4[3] / BUFFD8BWP7T30P140
Xi293 net387 vdd vss clk15 / BUFFD8BWP7T30P140
Xi292 net387 vdd vss clk14 / BUFFD8BWP7T30P140
Xi291 net387 vdd vss clk13 / BUFFD8BWP7T30P140
Xi290 net387 vdd vss clk12 / BUFFD8BWP7T30P140
Xi289 net387 vdd vss clk7 / BUFFD8BWP7T30P140
Xi288 net387 vdd vss clk6 / BUFFD8BWP7T30P140
Xi287 net387 vdd vss clk5 / BUFFD8BWP7T30P140
Xi286 net387 vdd vss clk4 / BUFFD8BWP7T30P140
Xi219 clk_in_asic vdd vss clk_asic_out_en / BUFFD8BWP7T30P140
MM0<0> vss vdd vss vss nch_18ud12_mac l=800n w=800n m=2 nf=1
MM0<1> vss vdd vss vss nch_18ud12_mac l=800n w=800n m=2 nf=1
MM0<2> vss vdd vss vss nch_18ud12_mac l=800n w=800n m=2 nf=1
MM0<3> vss vdd vss vss nch_18ud12_mac l=800n w=800n m=2 nf=1
MM0<4> vss vdd vss vss nch_18ud12_mac l=800n w=800n m=2 nf=1
MM0<5> vss vdd vss vss nch_18ud12_mac l=800n w=800n m=2 nf=1
MM0<6> vss vdd vss vss nch_18ud12_mac l=800n w=800n m=2 nf=1
MM0<7> vss vdd vss vss nch_18ud12_mac l=800n w=800n m=2 nf=1
MM0<8> vss vdd vss vss nch_18ud12_mac l=800n w=800n m=2 nf=1
MM0<9> vss vdd vss vss nch_18ud12_mac l=800n w=800n m=2 nf=1
MM0<10> vss vdd vss vss nch_18ud12_mac l=800n w=800n m=2 nf=1
MM0<11> vss vdd vss vss nch_18ud12_mac l=800n w=800n m=2 nf=1
MM0<12> vss vdd vss vss nch_18ud12_mac l=800n w=800n m=2 nf=1
MM0<13> vss vdd vss vss nch_18ud12_mac l=800n w=800n m=2 nf=1
MM0<14> vss vdd vss vss nch_18ud12_mac l=800n w=800n m=2 nf=1
MM0<15> vss vdd vss vss nch_18ud12_mac l=800n w=800n m=2 nf=1
MM0<16> vss vdd vss vss nch_18ud12_mac l=800n w=800n m=2 nf=1
MM0<17> vss vdd vss vss nch_18ud12_mac l=800n w=800n m=2 nf=1
MM0<18> vss vdd vss vss nch_18ud12_mac l=800n w=800n m=2 nf=1
MM0<19> vss vdd vss vss nch_18ud12_mac l=800n w=800n m=2 nf=1
MM0<20> vss vdd vss vss nch_18ud12_mac l=800n w=800n m=2 nf=1
MM0<21> vss vdd vss vss nch_18ud12_mac l=800n w=800n m=2 nf=1
MM0<22> vss vdd vss vss nch_18ud12_mac l=800n w=800n m=2 nf=1
MM0<23> vss vdd vss vss nch_18ud12_mac l=800n w=800n m=2 nf=1
MM0<24> vss vdd vss vss nch_18ud12_mac l=800n w=800n m=2 nf=1
MM0<25> vss vdd vss vss nch_18ud12_mac l=800n w=800n m=2 nf=1
MM0<26> vss vdd vss vss nch_18ud12_mac l=800n w=800n m=2 nf=1
MM0<27> vss vdd vss vss nch_18ud12_mac l=800n w=800n m=2 nf=1
MM0<28> vss vdd vss vss nch_18ud12_mac l=800n w=800n m=2 nf=1
MM0<29> vss vdd vss vss nch_18ud12_mac l=800n w=800n m=2 nf=1
MM0<30> vss vdd vss vss nch_18ud12_mac l=800n w=800n m=2 nf=1
MM0<31> vss vdd vss vss nch_18ud12_mac l=800n w=800n m=2 nf=1
MM0<32> vss vdd vss vss nch_18ud12_mac l=800n w=800n m=2 nf=1
MM0<33> vss vdd vss vss nch_18ud12_mac l=800n w=800n m=2 nf=1
MM0<34> vss vdd vss vss nch_18ud12_mac l=800n w=800n m=2 nf=1
MM0<35> vss vdd vss vss nch_18ud12_mac l=800n w=800n m=2 nf=1
MM0<36> vss vdd vss vss nch_18ud12_mac l=800n w=800n m=2 nf=1
MM0<37> vss vdd vss vss nch_18ud12_mac l=800n w=800n m=2 nf=1
MM0<38> vss vdd vss vss nch_18ud12_mac l=800n w=800n m=2 nf=1
MM0<39> vss vdd vss vss nch_18ud12_mac l=800n w=800n m=2 nf=1
MM0<40> vss vdd vss vss nch_18ud12_mac l=800n w=800n m=2 nf=1
MM0<41> vss vdd vss vss nch_18ud12_mac l=800n w=800n m=2 nf=1
MM0<42> vss vdd vss vss nch_18ud12_mac l=800n w=800n m=2 nf=1
MM0<43> vss vdd vss vss nch_18ud12_mac l=800n w=800n m=2 nf=1
MM0<44> vss vdd vss vss nch_18ud12_mac l=800n w=800n m=2 nf=1
MM0<45> vss vdd vss vss nch_18ud12_mac l=800n w=800n m=2 nf=1
MM0<46> vss vdd vss vss nch_18ud12_mac l=800n w=800n m=2 nf=1
MM0<47> vss vdd vss vss nch_18ud12_mac l=800n w=800n m=2 nf=1
MM0<48> vss vdd vss vss nch_18ud12_mac l=800n w=800n m=2 nf=1
MM0<49> vss vdd vss vss nch_18ud12_mac l=800n w=800n m=2 nf=1
MM0<50> vss vdd vss vss nch_18ud12_mac l=800n w=800n m=2 nf=1
MM0<51> vss vdd vss vss nch_18ud12_mac l=800n w=800n m=2 nf=1
MM0<52> vss vdd vss vss nch_18ud12_mac l=800n w=800n m=2 nf=1
MM0<53> vss vdd vss vss nch_18ud12_mac l=800n w=800n m=2 nf=1
MM0<54> vss vdd vss vss nch_18ud12_mac l=800n w=800n m=2 nf=1
MM0<55> vss vdd vss vss nch_18ud12_mac l=800n w=800n m=2 nf=1
MM0<56> vss vdd vss vss nch_18ud12_mac l=800n w=800n m=2 nf=1
MM0<57> vss vdd vss vss nch_18ud12_mac l=800n w=800n m=2 nf=1
MM0<58> vss vdd vss vss nch_18ud12_mac l=800n w=800n m=2 nf=1
MM0<59> vss vdd vss vss nch_18ud12_mac l=800n w=800n m=2 nf=1
MM0<60> vss vdd vss vss nch_18ud12_mac l=800n w=800n m=2 nf=1
MM0<61> vss vdd vss vss nch_18ud12_mac l=800n w=800n m=2 nf=1
MM0<62> vss vdd vss vss nch_18ud12_mac l=800n w=800n m=2 nf=1
MM0<63> vss vdd vss vss nch_18ud12_mac l=800n w=800n m=2 nf=1
MM0<64> vss vdd vss vss nch_18ud12_mac l=800n w=800n m=2 nf=1
MM0<65> vss vdd vss vss nch_18ud12_mac l=800n w=800n m=2 nf=1
MM0<66> vss vdd vss vss nch_18ud12_mac l=800n w=800n m=2 nf=1
MM0<67> vss vdd vss vss nch_18ud12_mac l=800n w=800n m=2 nf=1
MM0<68> vss vdd vss vss nch_18ud12_mac l=800n w=800n m=2 nf=1
MM0<69> vss vdd vss vss nch_18ud12_mac l=800n w=800n m=2 nf=1
MM0<70> vss vdd vss vss nch_18ud12_mac l=800n w=800n m=2 nf=1
MM0<71> vss vdd vss vss nch_18ud12_mac l=800n w=800n m=2 nf=1
MM0<72> vss vdd vss vss nch_18ud12_mac l=800n w=800n m=2 nf=1
MM0<73> vss vdd vss vss nch_18ud12_mac l=800n w=800n m=2 nf=1
MM0<74> vss vdd vss vss nch_18ud12_mac l=800n w=800n m=2 nf=1
MM0<75> vss vdd vss vss nch_18ud12_mac l=800n w=800n m=2 nf=1
MM0<76> vss vdd vss vss nch_18ud12_mac l=800n w=800n m=2 nf=1
MM0<77> vss vdd vss vss nch_18ud12_mac l=800n w=800n m=2 nf=1
MM0<78> vss vdd vss vss nch_18ud12_mac l=800n w=800n m=2 nf=1
MM0<79> vss vdd vss vss nch_18ud12_mac l=800n w=800n m=2 nf=1
MM0<80> vss vdd vss vss nch_18ud12_mac l=800n w=800n m=2 nf=1
MM0<81> vss vdd vss vss nch_18ud12_mac l=800n w=800n m=2 nf=1
MM0<82> vss vdd vss vss nch_18ud12_mac l=800n w=800n m=2 nf=1
MM0<83> vss vdd vss vss nch_18ud12_mac l=800n w=800n m=2 nf=1
MM0<84> vss vdd vss vss nch_18ud12_mac l=800n w=800n m=2 nf=1
MM0<85> vss vdd vss vss nch_18ud12_mac l=800n w=800n m=2 nf=1
MM0<86> vss vdd vss vss nch_18ud12_mac l=800n w=800n m=2 nf=1
MM0<87> vss vdd vss vss nch_18ud12_mac l=800n w=800n m=2 nf=1
MM0<88> vss vdd vss vss nch_18ud12_mac l=800n w=800n m=2 nf=1
MM0<89> vss vdd vss vss nch_18ud12_mac l=800n w=800n m=2 nf=1
MM0<90> vss vdd vss vss nch_18ud12_mac l=800n w=800n m=2 nf=1
MM0<91> vss vdd vss vss nch_18ud12_mac l=800n w=800n m=2 nf=1
MM0<92> vss vdd vss vss nch_18ud12_mac l=800n w=800n m=2 nf=1
MM0<93> vss vdd vss vss nch_18ud12_mac l=800n w=800n m=2 nf=1
MM0<94> vss vdd vss vss nch_18ud12_mac l=800n w=800n m=2 nf=1
MM0<95> vss vdd vss vss nch_18ud12_mac l=800n w=800n m=2 nf=1
MM0<96> vss vdd vss vss nch_18ud12_mac l=800n w=800n m=2 nf=1
MM0<97> vss vdd vss vss nch_18ud12_mac l=800n w=800n m=2 nf=1
MM0<98> vss vdd vss vss nch_18ud12_mac l=800n w=800n m=2 nf=1
MM0<99> vss vdd vss vss nch_18ud12_mac l=800n w=800n m=2 nf=1
MM0<100> vss vdd vss vss nch_18ud12_mac l=800n w=800n m=2 nf=1
MM0<101> vss vdd vss vss nch_18ud12_mac l=800n w=800n m=2 nf=1
MM0<102> vss vdd vss vss nch_18ud12_mac l=800n w=800n m=2 nf=1
MM0<103> vss vdd vss vss nch_18ud12_mac l=800n w=800n m=2 nf=1
MM0<104> vss vdd vss vss nch_18ud12_mac l=800n w=800n m=2 nf=1
MM0<105> vss vdd vss vss nch_18ud12_mac l=800n w=800n m=2 nf=1
MM0<106> vss vdd vss vss nch_18ud12_mac l=800n w=800n m=2 nf=1
MM0<107> vss vdd vss vss nch_18ud12_mac l=800n w=800n m=2 nf=1
MM0<108> vss vdd vss vss nch_18ud12_mac l=800n w=800n m=2 nf=1
MM0<109> vss vdd vss vss nch_18ud12_mac l=800n w=800n m=2 nf=1
MM0<110> vss vdd vss vss nch_18ud12_mac l=800n w=800n m=2 nf=1
MM0<111> vss vdd vss vss nch_18ud12_mac l=800n w=800n m=2 nf=1
MM0<112> vss vdd vss vss nch_18ud12_mac l=800n w=800n m=2 nf=1
MM0<113> vss vdd vss vss nch_18ud12_mac l=800n w=800n m=2 nf=1
MM0<114> vss vdd vss vss nch_18ud12_mac l=800n w=800n m=2 nf=1
MM0<115> vss vdd vss vss nch_18ud12_mac l=800n w=800n m=2 nf=1
MM0<116> vss vdd vss vss nch_18ud12_mac l=800n w=800n m=2 nf=1
MM0<117> vss vdd vss vss nch_18ud12_mac l=800n w=800n m=2 nf=1
MM0<118> vss vdd vss vss nch_18ud12_mac l=800n w=800n m=2 nf=1
MM0<119> vss vdd vss vss nch_18ud12_mac l=800n w=800n m=2 nf=1
MM0<120> vss vdd vss vss nch_18ud12_mac l=800n w=800n m=2 nf=1
MM0<121> vss vdd vss vss nch_18ud12_mac l=800n w=800n m=2 nf=1
MM0<122> vss vdd vss vss nch_18ud12_mac l=800n w=800n m=2 nf=1
MM0<123> vss vdd vss vss nch_18ud12_mac l=800n w=800n m=2 nf=1
MM0<124> vss vdd vss vss nch_18ud12_mac l=800n w=800n m=2 nf=1
MM0<125> vss vdd vss vss nch_18ud12_mac l=800n w=800n m=2 nf=1
MM0<126> vss vdd vss vss nch_18ud12_mac l=800n w=800n m=2 nf=1
MM0<127> vss vdd vss vss nch_18ud12_mac l=800n w=800n m=2 nf=1
MM0<128> vss vdd vss vss nch_18ud12_mac l=800n w=800n m=2 nf=1
MM0<129> vss vdd vss vss nch_18ud12_mac l=800n w=800n m=2 nf=1
MM0<130> vss vdd vss vss nch_18ud12_mac l=800n w=800n m=2 nf=1
MM0<131> vss vdd vss vss nch_18ud12_mac l=800n w=800n m=2 nf=1
MM0<132> vss vdd vss vss nch_18ud12_mac l=800n w=800n m=2 nf=1
MM0<133> vss vdd vss vss nch_18ud12_mac l=800n w=800n m=2 nf=1
MM0<134> vss vdd vss vss nch_18ud12_mac l=800n w=800n m=2 nf=1
MM0<135> vss vdd vss vss nch_18ud12_mac l=800n w=800n m=2 nf=1
MM0<136> vss vdd vss vss nch_18ud12_mac l=800n w=800n m=2 nf=1
MM0<137> vss vdd vss vss nch_18ud12_mac l=800n w=800n m=2 nf=1
MM0<138> vss vdd vss vss nch_18ud12_mac l=800n w=800n m=2 nf=1
MM0<139> vss vdd vss vss nch_18ud12_mac l=800n w=800n m=2 nf=1
MM0<140> vss vdd vss vss nch_18ud12_mac l=800n w=800n m=2 nf=1
MM0<141> vss vdd vss vss nch_18ud12_mac l=800n w=800n m=2 nf=1
MM0<142> vss vdd vss vss nch_18ud12_mac l=800n w=800n m=2 nf=1
MM0<143> vss vdd vss vss nch_18ud12_mac l=800n w=800n m=2 nf=1
MM0<144> vss vdd vss vss nch_18ud12_mac l=800n w=800n m=2 nf=1
MM0<145> vss vdd vss vss nch_18ud12_mac l=800n w=800n m=2 nf=1
MM0<146> vss vdd vss vss nch_18ud12_mac l=800n w=800n m=2 nf=1
MM0<147> vss vdd vss vss nch_18ud12_mac l=800n w=800n m=2 nf=1
MM0<148> vss vdd vss vss nch_18ud12_mac l=800n w=800n m=2 nf=1
MM0<149> vss vdd vss vss nch_18ud12_mac l=800n w=800n m=2 nf=1
MM0<150> vss vdd vss vss nch_18ud12_mac l=800n w=800n m=2 nf=1
MM0<151> vss vdd vss vss nch_18ud12_mac l=800n w=800n m=2 nf=1
MM0<152> vss vdd vss vss nch_18ud12_mac l=800n w=800n m=2 nf=1
MM0<153> vss vdd vss vss nch_18ud12_mac l=800n w=800n m=2 nf=1
MM0<154> vss vdd vss vss nch_18ud12_mac l=800n w=800n m=2 nf=1
MM0<155> vss vdd vss vss nch_18ud12_mac l=800n w=800n m=2 nf=1
MM0<156> vss vdd vss vss nch_18ud12_mac l=800n w=800n m=2 nf=1
MM0<157> vss vdd vss vss nch_18ud12_mac l=800n w=800n m=2 nf=1
MM0<158> vss vdd vss vss nch_18ud12_mac l=800n w=800n m=2 nf=1
MM0<159> vss vdd vss vss nch_18ud12_mac l=800n w=800n m=2 nf=1
MM0<160> vss vdd vss vss nch_18ud12_mac l=800n w=800n m=2 nf=1
MM0<161> vss vdd vss vss nch_18ud12_mac l=800n w=800n m=2 nf=1
MM0<162> vss vdd vss vss nch_18ud12_mac l=800n w=800n m=2 nf=1
MM0<163> vss vdd vss vss nch_18ud12_mac l=800n w=800n m=2 nf=1
MM0<164> vss vdd vss vss nch_18ud12_mac l=800n w=800n m=2 nf=1
MM0<165> vss vdd vss vss nch_18ud12_mac l=800n w=800n m=2 nf=1
MM0<166> vss vdd vss vss nch_18ud12_mac l=800n w=800n m=2 nf=1
MM0<167> vss vdd vss vss nch_18ud12_mac l=800n w=800n m=2 nf=1
MM0<168> vss vdd vss vss nch_18ud12_mac l=800n w=800n m=2 nf=1
MM0<169> vss vdd vss vss nch_18ud12_mac l=800n w=800n m=2 nf=1
MM0<170> vss vdd vss vss nch_18ud12_mac l=800n w=800n m=2 nf=1
MM0<171> vss vdd vss vss nch_18ud12_mac l=800n w=800n m=2 nf=1
MM0<172> vss vdd vss vss nch_18ud12_mac l=800n w=800n m=2 nf=1
MM0<173> vss vdd vss vss nch_18ud12_mac l=800n w=800n m=2 nf=1
MM0<174> vss vdd vss vss nch_18ud12_mac l=800n w=800n m=2 nf=1
MM0<175> vss vdd vss vss nch_18ud12_mac l=800n w=800n m=2 nf=1
MM0<176> vss vdd vss vss nch_18ud12_mac l=800n w=800n m=2 nf=1
MM0<177> vss vdd vss vss nch_18ud12_mac l=800n w=800n m=2 nf=1
MM0<178> vss vdd vss vss nch_18ud12_mac l=800n w=800n m=2 nf=1
MM0<179> vss vdd vss vss nch_18ud12_mac l=800n w=800n m=2 nf=1
MM0<180> vss vdd vss vss nch_18ud12_mac l=800n w=800n m=2 nf=1
MM0<181> vss vdd vss vss nch_18ud12_mac l=800n w=800n m=2 nf=1
MM0<182> vss vdd vss vss nch_18ud12_mac l=800n w=800n m=2 nf=1
MM0<183> vss vdd vss vss nch_18ud12_mac l=800n w=800n m=2 nf=1
MM0<184> vss vdd vss vss nch_18ud12_mac l=800n w=800n m=2 nf=1
MM0<185> vss vdd vss vss nch_18ud12_mac l=800n w=800n m=2 nf=1
MM0<186> vss vdd vss vss nch_18ud12_mac l=800n w=800n m=2 nf=1
MM0<187> vss vdd vss vss nch_18ud12_mac l=800n w=800n m=2 nf=1
MM0<188> vss vdd vss vss nch_18ud12_mac l=800n w=800n m=2 nf=1
MM0<189> vss vdd vss vss nch_18ud12_mac l=800n w=800n m=2 nf=1
MM0<190> vss vdd vss vss nch_18ud12_mac l=800n w=800n m=2 nf=1
MM0<191> vss vdd vss vss nch_18ud12_mac l=800n w=800n m=2 nf=1
MM0<192> vss vdd vss vss nch_18ud12_mac l=800n w=800n m=2 nf=1
MM0<193> vss vdd vss vss nch_18ud12_mac l=800n w=800n m=2 nf=1
MM0<194> vss vdd vss vss nch_18ud12_mac l=800n w=800n m=2 nf=1
MM0<195> vss vdd vss vss nch_18ud12_mac l=800n w=800n m=2 nf=1
MM0<196> vss vdd vss vss nch_18ud12_mac l=800n w=800n m=2 nf=1
MM0<197> vss vdd vss vss nch_18ud12_mac l=800n w=800n m=2 nf=1
MM0<198> vss vdd vss vss nch_18ud12_mac l=800n w=800n m=2 nf=1
MM0<199> vss vdd vss vss nch_18ud12_mac l=800n w=800n m=2 nf=1
MM0<200> vss vdd vss vss nch_18ud12_mac l=800n w=800n m=2 nf=1
MM0<201> vss vdd vss vss nch_18ud12_mac l=800n w=800n m=2 nf=1
MM0<202> vss vdd vss vss nch_18ud12_mac l=800n w=800n m=2 nf=1
MM0<203> vss vdd vss vss nch_18ud12_mac l=800n w=800n m=2 nf=1
MM0<204> vss vdd vss vss nch_18ud12_mac l=800n w=800n m=2 nf=1
MM0<205> vss vdd vss vss nch_18ud12_mac l=800n w=800n m=2 nf=1
MM0<206> vss vdd vss vss nch_18ud12_mac l=800n w=800n m=2 nf=1
MM0<207> vss vdd vss vss nch_18ud12_mac l=800n w=800n m=2 nf=1
MM0<208> vss vdd vss vss nch_18ud12_mac l=800n w=800n m=2 nf=1
MM0<209> vss vdd vss vss nch_18ud12_mac l=800n w=800n m=2 nf=1
MM0<210> vss vdd vss vss nch_18ud12_mac l=800n w=800n m=2 nf=1
MM0<211> vss vdd vss vss nch_18ud12_mac l=800n w=800n m=2 nf=1
MM0<212> vss vdd vss vss nch_18ud12_mac l=800n w=800n m=2 nf=1
MM0<213> vss vdd vss vss nch_18ud12_mac l=800n w=800n m=2 nf=1
MM0<214> vss vdd vss vss nch_18ud12_mac l=800n w=800n m=2 nf=1
MM0<215> vss vdd vss vss nch_18ud12_mac l=800n w=800n m=2 nf=1
MM0<216> vss vdd vss vss nch_18ud12_mac l=800n w=800n m=2 nf=1
MM0<217> vss vdd vss vss nch_18ud12_mac l=800n w=800n m=2 nf=1
MM0<218> vss vdd vss vss nch_18ud12_mac l=800n w=800n m=2 nf=1
MM0<219> vss vdd vss vss nch_18ud12_mac l=800n w=800n m=2 nf=1
MM0<220> vss vdd vss vss nch_18ud12_mac l=800n w=800n m=2 nf=1
MM0<221> vss vdd vss vss nch_18ud12_mac l=800n w=800n m=2 nf=1
MM0<222> vss vdd vss vss nch_18ud12_mac l=800n w=800n m=2 nf=1
MM0<223> vss vdd vss vss nch_18ud12_mac l=800n w=800n m=2 nf=1
MM0<224> vss vdd vss vss nch_18ud12_mac l=800n w=800n m=2 nf=1
MM0<225> vss vdd vss vss nch_18ud12_mac l=800n w=800n m=2 nf=1
MM0<226> vss vdd vss vss nch_18ud12_mac l=800n w=800n m=2 nf=1
MM0<227> vss vdd vss vss nch_18ud12_mac l=800n w=800n m=2 nf=1
MM0<228> vss vdd vss vss nch_18ud12_mac l=800n w=800n m=2 nf=1
MM0<229> vss vdd vss vss nch_18ud12_mac l=800n w=800n m=2 nf=1
MM0<230> vss vdd vss vss nch_18ud12_mac l=800n w=800n m=2 nf=1
MM0<231> vss vdd vss vss nch_18ud12_mac l=800n w=800n m=2 nf=1
MM0<232> vss vdd vss vss nch_18ud12_mac l=800n w=800n m=2 nf=1
MM0<233> vss vdd vss vss nch_18ud12_mac l=800n w=800n m=2 nf=1
MM0<234> vss vdd vss vss nch_18ud12_mac l=800n w=800n m=2 nf=1
MM0<235> vss vdd vss vss nch_18ud12_mac l=800n w=800n m=2 nf=1
MM0<236> vss vdd vss vss nch_18ud12_mac l=800n w=800n m=2 nf=1
MM0<237> vss vdd vss vss nch_18ud12_mac l=800n w=800n m=2 nf=1
MM0<238> vss vdd vss vss nch_18ud12_mac l=800n w=800n m=2 nf=1
MM0<239> vss vdd vss vss nch_18ud12_mac l=800n w=800n m=2 nf=1
MM0<240> vss vdd vss vss nch_18ud12_mac l=800n w=800n m=2 nf=1
MM0<241> vss vdd vss vss nch_18ud12_mac l=800n w=800n m=2 nf=1
MM0<242> vss vdd vss vss nch_18ud12_mac l=800n w=800n m=2 nf=1
MM0<243> vss vdd vss vss nch_18ud12_mac l=800n w=800n m=2 nf=1
MM0<244> vss vdd vss vss nch_18ud12_mac l=800n w=800n m=2 nf=1
MM0<245> vss vdd vss vss nch_18ud12_mac l=800n w=800n m=2 nf=1
MM0<246> vss vdd vss vss nch_18ud12_mac l=800n w=800n m=2 nf=1
MM0<247> vss vdd vss vss nch_18ud12_mac l=800n w=800n m=2 nf=1
MM0<248> vss vdd vss vss nch_18ud12_mac l=800n w=800n m=2 nf=1
MM0<249> vss vdd vss vss nch_18ud12_mac l=800n w=800n m=2 nf=1
MM0<250> vss vdd vss vss nch_18ud12_mac l=800n w=800n m=2 nf=1
MM0<251> vss vdd vss vss nch_18ud12_mac l=800n w=800n m=2 nf=1
MM0<252> vss vdd vss vss nch_18ud12_mac l=800n w=800n m=2 nf=1
MM0<253> vss vdd vss vss nch_18ud12_mac l=800n w=800n m=2 nf=1
MM0<254> vss vdd vss vss nch_18ud12_mac l=800n w=800n m=2 nf=1
MM0<255> vss vdd vss vss nch_18ud12_mac l=800n w=800n m=2 nf=1
MM0<256> vss vdd vss vss nch_18ud12_mac l=800n w=800n m=2 nf=1
MM0<257> vss vdd vss vss nch_18ud12_mac l=800n w=800n m=2 nf=1
MM1<0> vss vdd_array vss vss nch_18ud12_mac l=800n w=450.0n m=2 nf=1
MM1<1> vss vdd_array vss vss nch_18ud12_mac l=800n w=450.0n m=2 nf=1
MM1<2> vss vdd_array vss vss nch_18ud12_mac l=800n w=450.0n m=2 nf=1
MM1<3> vss vdd_array vss vss nch_18ud12_mac l=800n w=450.0n m=2 nf=1
MM1<4> vss vdd_array vss vss nch_18ud12_mac l=800n w=450.0n m=2 nf=1
MM1<5> vss vdd_array vss vss nch_18ud12_mac l=800n w=450.0n m=2 nf=1
MM1<6> vss vdd_array vss vss nch_18ud12_mac l=800n w=450.0n m=2 nf=1
MM1<7> vss vdd_array vss vss nch_18ud12_mac l=800n w=450.0n m=2 nf=1
MM1<8> vss vdd_array vss vss nch_18ud12_mac l=800n w=450.0n m=2 nf=1
MM1<9> vss vdd_array vss vss nch_18ud12_mac l=800n w=450.0n m=2 nf=1
MM1<10> vss vdd_array vss vss nch_18ud12_mac l=800n w=450.0n m=2 nf=1
MM1<11> vss vdd_array vss vss nch_18ud12_mac l=800n w=450.0n m=2 nf=1
MM1<12> vss vdd_array vss vss nch_18ud12_mac l=800n w=450.0n m=2 nf=1
MM1<13> vss vdd_array vss vss nch_18ud12_mac l=800n w=450.0n m=2 nf=1
MM1<14> vss vdd_array vss vss nch_18ud12_mac l=800n w=450.0n m=2 nf=1
MM1<15> vss vdd_array vss vss nch_18ud12_mac l=800n w=450.0n m=2 nf=1
MM1<16> vss vdd_array vss vss nch_18ud12_mac l=800n w=450.0n m=2 nf=1
MM1<17> vss vdd_array vss vss nch_18ud12_mac l=800n w=450.0n m=2 nf=1
MM1<18> vss vdd_array vss vss nch_18ud12_mac l=800n w=450.0n m=2 nf=1
MM2<0> vss vdd_array vss vss nch_18ud12_mac l=800n w=800n m=2 nf=1
MM2<1> vss vdd_array vss vss nch_18ud12_mac l=800n w=800n m=2 nf=1
MM2<2> vss vdd_array vss vss nch_18ud12_mac l=800n w=800n m=2 nf=1
MM2<3> vss vdd_array vss vss nch_18ud12_mac l=800n w=800n m=2 nf=1
MM2<4> vss vdd_array vss vss nch_18ud12_mac l=800n w=800n m=2 nf=1
MM2<5> vss vdd_array vss vss nch_18ud12_mac l=800n w=800n m=2 nf=1
MM2<6> vss vdd_array vss vss nch_18ud12_mac l=800n w=800n m=2 nf=1
MM2<7> vss vdd_array vss vss nch_18ud12_mac l=800n w=800n m=2 nf=1
MM2<8> vss vdd_array vss vss nch_18ud12_mac l=800n w=800n m=2 nf=1
MM2<9> vss vdd_array vss vss nch_18ud12_mac l=800n w=800n m=2 nf=1
MM2<10> vss vdd_array vss vss nch_18ud12_mac l=800n w=800n m=2 nf=1
MM2<11> vss vdd_array vss vss nch_18ud12_mac l=800n w=800n m=2 nf=1
MM2<12> vss vdd_array vss vss nch_18ud12_mac l=800n w=800n m=2 nf=1
MM2<13> vss vdd_array vss vss nch_18ud12_mac l=800n w=800n m=2 nf=1
MM2<14> vss vdd_array vss vss nch_18ud12_mac l=800n w=800n m=2 nf=1
MM2<15> vss vdd_array vss vss nch_18ud12_mac l=800n w=800n m=2 nf=1
MM2<16> vss vdd_array vss vss nch_18ud12_mac l=800n w=800n m=2 nf=1
MM2<17> vss vdd_array vss vss nch_18ud12_mac l=800n w=800n m=2 nf=1
MM2<18> vss vdd_array vss vss nch_18ud12_mac l=800n w=800n m=2 nf=1
MM2<19> vss vdd_array vss vss nch_18ud12_mac l=800n w=800n m=2 nf=1
MM2<20> vss vdd_array vss vss nch_18ud12_mac l=800n w=800n m=2 nf=1
MM2<21> vss vdd_array vss vss nch_18ud12_mac l=800n w=800n m=2 nf=1
MM2<22> vss vdd_array vss vss nch_18ud12_mac l=800n w=800n m=2 nf=1
MM2<23> vss vdd_array vss vss nch_18ud12_mac l=800n w=800n m=2 nf=1
MM2<24> vss vdd_array vss vss nch_18ud12_mac l=800n w=800n m=2 nf=1
MM2<25> vss vdd_array vss vss nch_18ud12_mac l=800n w=800n m=2 nf=1
MM2<26> vss vdd_array vss vss nch_18ud12_mac l=800n w=800n m=2 nf=1
MM2<27> vss vdd_array vss vss nch_18ud12_mac l=800n w=800n m=2 nf=1
MM2<28> vss vdd_array vss vss nch_18ud12_mac l=800n w=800n m=2 nf=1
MM2<29> vss vdd_array vss vss nch_18ud12_mac l=800n w=800n m=2 nf=1
MM2<30> vss vdd_array vss vss nch_18ud12_mac l=800n w=800n m=2 nf=1
MM2<31> vss vdd_array vss vss nch_18ud12_mac l=800n w=800n m=2 nf=1
MM2<32> vss vdd_array vss vss nch_18ud12_mac l=800n w=800n m=2 nf=1
MM2<33> vss vdd_array vss vss nch_18ud12_mac l=800n w=800n m=2 nf=1
MM2<34> vss vdd_array vss vss nch_18ud12_mac l=800n w=800n m=2 nf=1
MM2<35> vss vdd_array vss vss nch_18ud12_mac l=800n w=800n m=2 nf=1
MM2<36> vss vdd_array vss vss nch_18ud12_mac l=800n w=800n m=2 nf=1
MM2<37> vss vdd_array vss vss nch_18ud12_mac l=800n w=800n m=2 nf=1
MM2<38> vss vdd_array vss vss nch_18ud12_mac l=800n w=800n m=2 nf=1
MM2<39> vss vdd_array vss vss nch_18ud12_mac l=800n w=800n m=2 nf=1
MM2<40> vss vdd_array vss vss nch_18ud12_mac l=800n w=800n m=2 nf=1
MM2<41> vss vdd_array vss vss nch_18ud12_mac l=800n w=800n m=2 nf=1
MM2<42> vss vdd_array vss vss nch_18ud12_mac l=800n w=800n m=2 nf=1
MM2<43> vss vdd_array vss vss nch_18ud12_mac l=800n w=800n m=2 nf=1
MM2<44> vss vdd_array vss vss nch_18ud12_mac l=800n w=800n m=2 nf=1
MM2<45> vss vdd_array vss vss nch_18ud12_mac l=800n w=800n m=2 nf=1
MM2<46> vss vdd_array vss vss nch_18ud12_mac l=800n w=800n m=2 nf=1
MM2<47> vss vdd_array vss vss nch_18ud12_mac l=800n w=800n m=2 nf=1
MM2<48> vss vdd_array vss vss nch_18ud12_mac l=800n w=800n m=2 nf=1
MM2<49> vss vdd_array vss vss nch_18ud12_mac l=800n w=800n m=2 nf=1
MM2<50> vss vdd_array vss vss nch_18ud12_mac l=800n w=800n m=2 nf=1
MM2<51> vss vdd_array vss vss nch_18ud12_mac l=800n w=800n m=2 nf=1
MM2<52> vss vdd_array vss vss nch_18ud12_mac l=800n w=800n m=2 nf=1
MM2<53> vss vdd_array vss vss nch_18ud12_mac l=800n w=800n m=2 nf=1
MM2<54> vss vdd_array vss vss nch_18ud12_mac l=800n w=800n m=2 nf=1
MM2<55> vss vdd_array vss vss nch_18ud12_mac l=800n w=800n m=2 nf=1
MM2<56> vss vdd_array vss vss nch_18ud12_mac l=800n w=800n m=2 nf=1
MM2<57> vss vdd_array vss vss nch_18ud12_mac l=800n w=800n m=2 nf=1
MM2<58> vss vdd_array vss vss nch_18ud12_mac l=800n w=800n m=2 nf=1
MM2<59> vss vdd_array vss vss nch_18ud12_mac l=800n w=800n m=2 nf=1
MM2<60> vss vdd_array vss vss nch_18ud12_mac l=800n w=800n m=2 nf=1
MM2<61> vss vdd_array vss vss nch_18ud12_mac l=800n w=800n m=2 nf=1
MM2<62> vss vdd_array vss vss nch_18ud12_mac l=800n w=800n m=2 nf=1
MM2<63> vss vdd_array vss vss nch_18ud12_mac l=800n w=800n m=2 nf=1
MM2<64> vss vdd_array vss vss nch_18ud12_mac l=800n w=800n m=2 nf=1
MM2<65> vss vdd_array vss vss nch_18ud12_mac l=800n w=800n m=2 nf=1
MM2<66> vss vdd_array vss vss nch_18ud12_mac l=800n w=800n m=2 nf=1
MM2<67> vss vdd_array vss vss nch_18ud12_mac l=800n w=800n m=2 nf=1
MM2<68> vss vdd_array vss vss nch_18ud12_mac l=800n w=800n m=2 nf=1
MM2<69> vss vdd_array vss vss nch_18ud12_mac l=800n w=800n m=2 nf=1
MM2<70> vss vdd_array vss vss nch_18ud12_mac l=800n w=800n m=2 nf=1
MM2<71> vss vdd_array vss vss nch_18ud12_mac l=800n w=800n m=2 nf=1
MM2<72> vss vdd_array vss vss nch_18ud12_mac l=800n w=800n m=2 nf=1
MM2<73> vss vdd_array vss vss nch_18ud12_mac l=800n w=800n m=2 nf=1
MM2<74> vss vdd_array vss vss nch_18ud12_mac l=800n w=800n m=2 nf=1
MM2<75> vss vdd_array vss vss nch_18ud12_mac l=800n w=800n m=2 nf=1
MM2<76> vss vdd_array vss vss nch_18ud12_mac l=800n w=800n m=2 nf=1
MM2<77> vss vdd_array vss vss nch_18ud12_mac l=800n w=800n m=2 nf=1
MM2<78> vss vdd_array vss vss nch_18ud12_mac l=800n w=800n m=2 nf=1
MM2<79> vss vdd_array vss vss nch_18ud12_mac l=800n w=800n m=2 nf=1
MM2<80> vss vdd_array vss vss nch_18ud12_mac l=800n w=800n m=2 nf=1
MM2<81> vss vdd_array vss vss nch_18ud12_mac l=800n w=800n m=2 nf=1
MM2<82> vss vdd_array vss vss nch_18ud12_mac l=800n w=800n m=2 nf=1
MM2<83> vss vdd_array vss vss nch_18ud12_mac l=800n w=800n m=2 nf=1
MM2<84> vss vdd_array vss vss nch_18ud12_mac l=800n w=800n m=2 nf=1
MM2<85> vss vdd_array vss vss nch_18ud12_mac l=800n w=800n m=2 nf=1
MM2<86> vss vdd_array vss vss nch_18ud12_mac l=800n w=800n m=2 nf=1
MM2<87> vss vdd_array vss vss nch_18ud12_mac l=800n w=800n m=2 nf=1
MM2<88> vss vdd_array vss vss nch_18ud12_mac l=800n w=800n m=2 nf=1
MM2<89> vss vdd_array vss vss nch_18ud12_mac l=800n w=800n m=2 nf=1
MM2<90> vss vdd_array vss vss nch_18ud12_mac l=800n w=800n m=2 nf=1
MM2<91> vss vdd_array vss vss nch_18ud12_mac l=800n w=800n m=2 nf=1
MM2<92> vss vdd_array vss vss nch_18ud12_mac l=800n w=800n m=2 nf=1
MM2<93> vss vdd_array vss vss nch_18ud12_mac l=800n w=800n m=2 nf=1
MM2<94> vss vdd_array vss vss nch_18ud12_mac l=800n w=800n m=2 nf=1
MM2<95> vss vdd_array vss vss nch_18ud12_mac l=800n w=800n m=2 nf=1
MM2<96> vss vdd_array vss vss nch_18ud12_mac l=800n w=800n m=2 nf=1
MM2<97> vss vdd_array vss vss nch_18ud12_mac l=800n w=800n m=2 nf=1
MM2<98> vss vdd_array vss vss nch_18ud12_mac l=800n w=800n m=2 nf=1
MM2<99> vss vdd_array vss vss nch_18ud12_mac l=800n w=800n m=2 nf=1
MM2<100> vss vdd_array vss vss nch_18ud12_mac l=800n w=800n m=2 nf=1
MM2<101> vss vdd_array vss vss nch_18ud12_mac l=800n w=800n m=2 nf=1
MM2<102> vss vdd_array vss vss nch_18ud12_mac l=800n w=800n m=2 nf=1
MM2<103> vss vdd_array vss vss nch_18ud12_mac l=800n w=800n m=2 nf=1
MM2<104> vss vdd_array vss vss nch_18ud12_mac l=800n w=800n m=2 nf=1
MM2<105> vss vdd_array vss vss nch_18ud12_mac l=800n w=800n m=2 nf=1
MM2<106> vss vdd_array vss vss nch_18ud12_mac l=800n w=800n m=2 nf=1
MM2<107> vss vdd_array vss vss nch_18ud12_mac l=800n w=800n m=2 nf=1
MM2<108> vss vdd_array vss vss nch_18ud12_mac l=800n w=800n m=2 nf=1
MM2<109> vss vdd_array vss vss nch_18ud12_mac l=800n w=800n m=2 nf=1
MM2<110> vss vdd_array vss vss nch_18ud12_mac l=800n w=800n m=2 nf=1
MM2<111> vss vdd_array vss vss nch_18ud12_mac l=800n w=800n m=2 nf=1
MM2<112> vss vdd_array vss vss nch_18ud12_mac l=800n w=800n m=2 nf=1
MM2<113> vss vdd_array vss vss nch_18ud12_mac l=800n w=800n m=2 nf=1
MM2<114> vss vdd_array vss vss nch_18ud12_mac l=800n w=800n m=2 nf=1
MM2<115> vss vdd_array vss vss nch_18ud12_mac l=800n w=800n m=2 nf=1
MM2<116> vss vdd_array vss vss nch_18ud12_mac l=800n w=800n m=2 nf=1
MM2<117> vss vdd_array vss vss nch_18ud12_mac l=800n w=800n m=2 nf=1
MM2<118> vss vdd_array vss vss nch_18ud12_mac l=800n w=800n m=2 nf=1
MM2<119> vss vdd_array vss vss nch_18ud12_mac l=800n w=800n m=2 nf=1
MM2<120> vss vdd_array vss vss nch_18ud12_mac l=800n w=800n m=2 nf=1
MM2<121> vss vdd_array vss vss nch_18ud12_mac l=800n w=800n m=2 nf=1
MM2<122> vss vdd_array vss vss nch_18ud12_mac l=800n w=800n m=2 nf=1
MM2<123> vss vdd_array vss vss nch_18ud12_mac l=800n w=800n m=2 nf=1
MM2<124> vss vdd_array vss vss nch_18ud12_mac l=800n w=800n m=2 nf=1
MM2<125> vss vdd_array vss vss nch_18ud12_mac l=800n w=800n m=2 nf=1
MM2<126> vss vdd_array vss vss nch_18ud12_mac l=800n w=800n m=2 nf=1
MM2<127> vss vdd_array vss vss nch_18ud12_mac l=800n w=800n m=2 nf=1
MM2<128> vss vdd_array vss vss nch_18ud12_mac l=800n w=800n m=2 nf=1
MM2<129> vss vdd_array vss vss nch_18ud12_mac l=800n w=800n m=2 nf=1
MM2<130> vss vdd_array vss vss nch_18ud12_mac l=800n w=800n m=2 nf=1
MM2<131> vss vdd_array vss vss nch_18ud12_mac l=800n w=800n m=2 nf=1
MM2<132> vss vdd_array vss vss nch_18ud12_mac l=800n w=800n m=2 nf=1
MM2<133> vss vdd_array vss vss nch_18ud12_mac l=800n w=800n m=2 nf=1
MM2<134> vss vdd_array vss vss nch_18ud12_mac l=800n w=800n m=2 nf=1
MM2<135> vss vdd_array vss vss nch_18ud12_mac l=800n w=800n m=2 nf=1
MM2<136> vss vdd_array vss vss nch_18ud12_mac l=800n w=800n m=2 nf=1
MM2<137> vss vdd_array vss vss nch_18ud12_mac l=800n w=800n m=2 nf=1
MM2<138> vss vdd_array vss vss nch_18ud12_mac l=800n w=800n m=2 nf=1
MM2<139> vss vdd_array vss vss nch_18ud12_mac l=800n w=800n m=2 nf=1
MM2<140> vss vdd_array vss vss nch_18ud12_mac l=800n w=800n m=2 nf=1
MM2<141> vss vdd_array vss vss nch_18ud12_mac l=800n w=800n m=2 nf=1
MM2<142> vss vdd_array vss vss nch_18ud12_mac l=800n w=800n m=2 nf=1
MM2<143> vss vdd_array vss vss nch_18ud12_mac l=800n w=800n m=2 nf=1
MM2<144> vss vdd_array vss vss nch_18ud12_mac l=800n w=800n m=2 nf=1
MM2<145> vss vdd_array vss vss nch_18ud12_mac l=800n w=800n m=2 nf=1
MM2<146> vss vdd_array vss vss nch_18ud12_mac l=800n w=800n m=2 nf=1
MM2<147> vss vdd_array vss vss nch_18ud12_mac l=800n w=800n m=2 nf=1
MM2<148> vss vdd_array vss vss nch_18ud12_mac l=800n w=800n m=2 nf=1
MM2<149> vss vdd_array vss vss nch_18ud12_mac l=800n w=800n m=2 nf=1
MM2<150> vss vdd_array vss vss nch_18ud12_mac l=800n w=800n m=2 nf=1
MM2<151> vss vdd_array vss vss nch_18ud12_mac l=800n w=800n m=2 nf=1
MM2<152> vss vdd_array vss vss nch_18ud12_mac l=800n w=800n m=2 nf=1
MM2<153> vss vdd_array vss vss nch_18ud12_mac l=800n w=800n m=2 nf=1
MM2<154> vss vdd_array vss vss nch_18ud12_mac l=800n w=800n m=2 nf=1
MM2<155> vss vdd_array vss vss nch_18ud12_mac l=800n w=800n m=2 nf=1
MM2<156> vss vdd_array vss vss nch_18ud12_mac l=800n w=800n m=2 nf=1
MM2<157> vss vdd_array vss vss nch_18ud12_mac l=800n w=800n m=2 nf=1
MM2<158> vss vdd_array vss vss nch_18ud12_mac l=800n w=800n m=2 nf=1
MM2<159> vss vdd_array vss vss nch_18ud12_mac l=800n w=800n m=2 nf=1
MM2<160> vss vdd_array vss vss nch_18ud12_mac l=800n w=800n m=2 nf=1
MM2<161> vss vdd_array vss vss nch_18ud12_mac l=800n w=800n m=2 nf=1
MM2<162> vss vdd_array vss vss nch_18ud12_mac l=800n w=800n m=2 nf=1
MM2<163> vss vdd_array vss vss nch_18ud12_mac l=800n w=800n m=2 nf=1
MM2<164> vss vdd_array vss vss nch_18ud12_mac l=800n w=800n m=2 nf=1
MM2<165> vss vdd_array vss vss nch_18ud12_mac l=800n w=800n m=2 nf=1
MM2<166> vss vdd_array vss vss nch_18ud12_mac l=800n w=800n m=2 nf=1
MM2<167> vss vdd_array vss vss nch_18ud12_mac l=800n w=800n m=2 nf=1
MM2<168> vss vdd_array vss vss nch_18ud12_mac l=800n w=800n m=2 nf=1
MM2<169> vss vdd_array vss vss nch_18ud12_mac l=800n w=800n m=2 nf=1
MM2<170> vss vdd_array vss vss nch_18ud12_mac l=800n w=800n m=2 nf=1
MM2<171> vss vdd_array vss vss nch_18ud12_mac l=800n w=800n m=2 nf=1
MM2<172> vss vdd_array vss vss nch_18ud12_mac l=800n w=800n m=2 nf=1
MM2<173> vss vdd_array vss vss nch_18ud12_mac l=800n w=800n m=2 nf=1
MM2<174> vss vdd_array vss vss nch_18ud12_mac l=800n w=800n m=2 nf=1
MM2<175> vss vdd_array vss vss nch_18ud12_mac l=800n w=800n m=2 nf=1
MM2<176> vss vdd_array vss vss nch_18ud12_mac l=800n w=800n m=2 nf=1
MM2<177> vss vdd_array vss vss nch_18ud12_mac l=800n w=800n m=2 nf=1
MM2<178> vss vdd_array vss vss nch_18ud12_mac l=800n w=800n m=2 nf=1
MM2<179> vss vdd_array vss vss nch_18ud12_mac l=800n w=800n m=2 nf=1
MM2<180> vss vdd_array vss vss nch_18ud12_mac l=800n w=800n m=2 nf=1
MM2<181> vss vdd_array vss vss nch_18ud12_mac l=800n w=800n m=2 nf=1
MM2<182> vss vdd_array vss vss nch_18ud12_mac l=800n w=800n m=2 nf=1
MM2<183> vss vdd_array vss vss nch_18ud12_mac l=800n w=800n m=2 nf=1
MM2<184> vss vdd_array vss vss nch_18ud12_mac l=800n w=800n m=2 nf=1
MM2<185> vss vdd_array vss vss nch_18ud12_mac l=800n w=800n m=2 nf=1
MM2<186> vss vdd_array vss vss nch_18ud12_mac l=800n w=800n m=2 nf=1
MM2<187> vss vdd_array vss vss nch_18ud12_mac l=800n w=800n m=2 nf=1
MM2<188> vss vdd_array vss vss nch_18ud12_mac l=800n w=800n m=2 nf=1
MM2<189> vss vdd_array vss vss nch_18ud12_mac l=800n w=800n m=2 nf=1
MM2<190> vss vdd_array vss vss nch_18ud12_mac l=800n w=800n m=2 nf=1
MM2<191> vss vdd_array vss vss nch_18ud12_mac l=800n w=800n m=2 nf=1
MM2<192> vss vdd_array vss vss nch_18ud12_mac l=800n w=800n m=2 nf=1
MM2<193> vss vdd_array vss vss nch_18ud12_mac l=800n w=800n m=2 nf=1
MM2<194> vss vdd_array vss vss nch_18ud12_mac l=800n w=800n m=2 nf=1
MM2<195> vss vdd_array vss vss nch_18ud12_mac l=800n w=800n m=2 nf=1
MM2<196> vss vdd_array vss vss nch_18ud12_mac l=800n w=800n m=2 nf=1
MM2<197> vss vdd_array vss vss nch_18ud12_mac l=800n w=800n m=2 nf=1
MM2<198> vss vdd_array vss vss nch_18ud12_mac l=800n w=800n m=2 nf=1
MM2<199> vss vdd_array vss vss nch_18ud12_mac l=800n w=800n m=2 nf=1
MM2<200> vss vdd_array vss vss nch_18ud12_mac l=800n w=800n m=2 nf=1
MM2<201> vss vdd_array vss vss nch_18ud12_mac l=800n w=800n m=2 nf=1
MM2<202> vss vdd_array vss vss nch_18ud12_mac l=800n w=800n m=2 nf=1
MM2<203> vss vdd_array vss vss nch_18ud12_mac l=800n w=800n m=2 nf=1
MM2<204> vss vdd_array vss vss nch_18ud12_mac l=800n w=800n m=2 nf=1
MM2<205> vss vdd_array vss vss nch_18ud12_mac l=800n w=800n m=2 nf=1
MM2<206> vss vdd_array vss vss nch_18ud12_mac l=800n w=800n m=2 nf=1
MM2<207> vss vdd_array vss vss nch_18ud12_mac l=800n w=800n m=2 nf=1
MM2<208> vss vdd_array vss vss nch_18ud12_mac l=800n w=800n m=2 nf=1
MM2<209> vss vdd_array vss vss nch_18ud12_mac l=800n w=800n m=2 nf=1
MM2<210> vss vdd_array vss vss nch_18ud12_mac l=800n w=800n m=2 nf=1
MM2<211> vss vdd_array vss vss nch_18ud12_mac l=800n w=800n m=2 nf=1
MM2<212> vss vdd_array vss vss nch_18ud12_mac l=800n w=800n m=2 nf=1
MM2<213> vss vdd_array vss vss nch_18ud12_mac l=800n w=800n m=2 nf=1
MM2<214> vss vdd_array vss vss nch_18ud12_mac l=800n w=800n m=2 nf=1
MM2<215> vss vdd_array vss vss nch_18ud12_mac l=800n w=800n m=2 nf=1
MM2<216> vss vdd_array vss vss nch_18ud12_mac l=800n w=800n m=2 nf=1
MM2<217> vss vdd_array vss vss nch_18ud12_mac l=800n w=800n m=2 nf=1
MM2<218> vss vdd_array vss vss nch_18ud12_mac l=800n w=800n m=2 nf=1
MM2<219> vss vdd_array vss vss nch_18ud12_mac l=800n w=800n m=2 nf=1
MM2<220> vss vdd_array vss vss nch_18ud12_mac l=800n w=800n m=2 nf=1
MM2<221> vss vdd_array vss vss nch_18ud12_mac l=800n w=800n m=2 nf=1
MM2<222> vss vdd_array vss vss nch_18ud12_mac l=800n w=800n m=2 nf=1
MM2<223> vss vdd_array vss vss nch_18ud12_mac l=800n w=800n m=2 nf=1
MM2<224> vss vdd_array vss vss nch_18ud12_mac l=800n w=800n m=2 nf=1
MM2<225> vss vdd_array vss vss nch_18ud12_mac l=800n w=800n m=2 nf=1
MM2<226> vss vdd_array vss vss nch_18ud12_mac l=800n w=800n m=2 nf=1
MM2<227> vss vdd_array vss vss nch_18ud12_mac l=800n w=800n m=2 nf=1
MM2<228> vss vdd_array vss vss nch_18ud12_mac l=800n w=800n m=2 nf=1
MM2<229> vss vdd_array vss vss nch_18ud12_mac l=800n w=800n m=2 nf=1
MM2<230> vss vdd_array vss vss nch_18ud12_mac l=800n w=800n m=2 nf=1
MM2<231> vss vdd_array vss vss nch_18ud12_mac l=800n w=800n m=2 nf=1
MM2<232> vss vdd_array vss vss nch_18ud12_mac l=800n w=800n m=2 nf=1
MM2<233> vss vdd_array vss vss nch_18ud12_mac l=800n w=800n m=2 nf=1
MM2<234> vss vdd_array vss vss nch_18ud12_mac l=800n w=800n m=2 nf=1
MM2<235> vss vdd_array vss vss nch_18ud12_mac l=800n w=800n m=2 nf=1
MM2<236> vss vdd_array vss vss nch_18ud12_mac l=800n w=800n m=2 nf=1
MM2<237> vss vdd_array vss vss nch_18ud12_mac l=800n w=800n m=2 nf=1
MM2<238> vss vdd_array vss vss nch_18ud12_mac l=800n w=800n m=2 nf=1
MM2<239> vss vdd_array vss vss nch_18ud12_mac l=800n w=800n m=2 nf=1
MM2<240> vss vdd_array vss vss nch_18ud12_mac l=800n w=800n m=2 nf=1
MM2<241> vss vdd_array vss vss nch_18ud12_mac l=800n w=800n m=2 nf=1
MM2<242> vss vdd_array vss vss nch_18ud12_mac l=800n w=800n m=2 nf=1
MM2<243> vss vdd_array vss vss nch_18ud12_mac l=800n w=800n m=2 nf=1
MM2<244> vss vdd_array vss vss nch_18ud12_mac l=800n w=800n m=2 nf=1
MM2<245> vss vdd_array vss vss nch_18ud12_mac l=800n w=800n m=2 nf=1
MM2<246> vss vdd_array vss vss nch_18ud12_mac l=800n w=800n m=2 nf=1
MM2<247> vss vdd_array vss vss nch_18ud12_mac l=800n w=800n m=2 nf=1
MM2<248> vss vdd_array vss vss nch_18ud12_mac l=800n w=800n m=2 nf=1
MM2<249> vss vdd_array vss vss nch_18ud12_mac l=800n w=800n m=2 nf=1
MM2<250> vss vdd_array vss vss nch_18ud12_mac l=800n w=800n m=2 nf=1
MM2<251> vss vdd_array vss vss nch_18ud12_mac l=800n w=800n m=2 nf=1
MM2<252> vss vdd_array vss vss nch_18ud12_mac l=800n w=800n m=2 nf=1
MM2<253> vss vdd_array vss vss nch_18ud12_mac l=800n w=800n m=2 nf=1
MM2<254> vss vdd_array vss vss nch_18ud12_mac l=800n w=800n m=2 nf=1
MM2<255> vss vdd_array vss vss nch_18ud12_mac l=800n w=800n m=2 nf=1
MM2<256> vss vdd_array vss vss nch_18ud12_mac l=800n w=800n m=2 nf=1
MM2<257> vss vdd_array vss vss nch_18ud12_mac l=800n w=800n m=2 nf=1
MM2<258> vss vdd_array vss vss nch_18ud12_mac l=800n w=800n m=2 nf=1
MM2<259> vss vdd_array vss vss nch_18ud12_mac l=800n w=800n m=2 nf=1
MM2<260> vss vdd_array vss vss nch_18ud12_mac l=800n w=800n m=2 nf=1
MM2<261> vss vdd_array vss vss nch_18ud12_mac l=800n w=800n m=2 nf=1
MM2<262> vss vdd_array vss vss nch_18ud12_mac l=800n w=800n m=2 nf=1
MM2<263> vss vdd_array vss vss nch_18ud12_mac l=800n w=800n m=2 nf=1
MM2<264> vss vdd_array vss vss nch_18ud12_mac l=800n w=800n m=2 nf=1
MM2<265> vss vdd_array vss vss nch_18ud12_mac l=800n w=800n m=2 nf=1
MM2<266> vss vdd_array vss vss nch_18ud12_mac l=800n w=800n m=2 nf=1
MM2<267> vss vdd_array vss vss nch_18ud12_mac l=800n w=800n m=2 nf=1
MM2<268> vss vdd_array vss vss nch_18ud12_mac l=800n w=800n m=2 nf=1
MM2<269> vss vdd_array vss vss nch_18ud12_mac l=800n w=800n m=2 nf=1
MM2<270> vss vdd_array vss vss nch_18ud12_mac l=800n w=800n m=2 nf=1
MM2<271> vss vdd_array vss vss nch_18ud12_mac l=800n w=800n m=2 nf=1
MM2<272> vss vdd_array vss vss nch_18ud12_mac l=800n w=800n m=2 nf=1
MM2<273> vss vdd_array vss vss nch_18ud12_mac l=800n w=800n m=2 nf=1
MM2<274> vss vdd_array vss vss nch_18ud12_mac l=800n w=800n m=2 nf=1
MM2<275> vss vdd_array vss vss nch_18ud12_mac l=800n w=800n m=2 nf=1
MM2<276> vss vdd_array vss vss nch_18ud12_mac l=800n w=800n m=2 nf=1
MM2<277> vss vdd_array vss vss nch_18ud12_mac l=800n w=800n m=2 nf=1
MM2<278> vss vdd_array vss vss nch_18ud12_mac l=800n w=800n m=2 nf=1
MM2<279> vss vdd_array vss vss nch_18ud12_mac l=800n w=800n m=2 nf=1
MM2<280> vss vdd_array vss vss nch_18ud12_mac l=800n w=800n m=2 nf=1
MM2<281> vss vdd_array vss vss nch_18ud12_mac l=800n w=800n m=2 nf=1
MM2<282> vss vdd_array vss vss nch_18ud12_mac l=800n w=800n m=2 nf=1
MM2<283> vss vdd_array vss vss nch_18ud12_mac l=800n w=800n m=2 nf=1
MM2<284> vss vdd_array vss vss nch_18ud12_mac l=800n w=800n m=2 nf=1
MM2<285> vss vdd_array vss vss nch_18ud12_mac l=800n w=800n m=2 nf=1
MM2<286> vss vdd_array vss vss nch_18ud12_mac l=800n w=800n m=2 nf=1
MM2<287> vss vdd_array vss vss nch_18ud12_mac l=800n w=800n m=2 nf=1
MM2<288> vss vdd_array vss vss nch_18ud12_mac l=800n w=800n m=2 nf=1
MM2<289> vss vdd_array vss vss nch_18ud12_mac l=800n w=800n m=2 nf=1
MM2<290> vss vdd_array vss vss nch_18ud12_mac l=800n w=800n m=2 nf=1
MM2<291> vss vdd_array vss vss nch_18ud12_mac l=800n w=800n m=2 nf=1
MM2<292> vss vdd_array vss vss nch_18ud12_mac l=800n w=800n m=2 nf=1
MM2<293> vss vdd_array vss vss nch_18ud12_mac l=800n w=800n m=2 nf=1
MM2<294> vss vdd_array vss vss nch_18ud12_mac l=800n w=800n m=2 nf=1
MM2<295> vss vdd_array vss vss nch_18ud12_mac l=800n w=800n m=2 nf=1
MM2<296> vss vdd_array vss vss nch_18ud12_mac l=800n w=800n m=2 nf=1
MM2<297> vss vdd_array vss vss nch_18ud12_mac l=800n w=800n m=2 nf=1
MM2<298> vss vdd_array vss vss nch_18ud12_mac l=800n w=800n m=2 nf=1
MM2<299> vss vdd_array vss vss nch_18ud12_mac l=800n w=800n m=2 nf=1
MM2<300> vss vdd_array vss vss nch_18ud12_mac l=800n w=800n m=2 nf=1
MM2<301> vss vdd_array vss vss nch_18ud12_mac l=800n w=800n m=2 nf=1
MM2<302> vss vdd_array vss vss nch_18ud12_mac l=800n w=800n m=2 nf=1
MM2<303> vss vdd_array vss vss nch_18ud12_mac l=800n w=800n m=2 nf=1
MM2<304> vss vdd_array vss vss nch_18ud12_mac l=800n w=800n m=2 nf=1
MM2<305> vss vdd_array vss vss nch_18ud12_mac l=800n w=800n m=2 nf=1
MM2<306> vss vdd_array vss vss nch_18ud12_mac l=800n w=800n m=2 nf=1
MM2<307> vss vdd_array vss vss nch_18ud12_mac l=800n w=800n m=2 nf=1
MM2<308> vss vdd_array vss vss nch_18ud12_mac l=800n w=800n m=2 nf=1
MM2<309> vss vdd_array vss vss nch_18ud12_mac l=800n w=800n m=2 nf=1
MM2<310> vss vdd_array vss vss nch_18ud12_mac l=800n w=800n m=2 nf=1
MM2<311> vss vdd_array vss vss nch_18ud12_mac l=800n w=800n m=2 nf=1
MM2<312> vss vdd_array vss vss nch_18ud12_mac l=800n w=800n m=2 nf=1
MM2<313> vss vdd_array vss vss nch_18ud12_mac l=800n w=800n m=2 nf=1
MM2<314> vss vdd_array vss vss nch_18ud12_mac l=800n w=800n m=2 nf=1
MM2<315> vss vdd_array vss vss nch_18ud12_mac l=800n w=800n m=2 nf=1
MM2<316> vss vdd_array vss vss nch_18ud12_mac l=800n w=800n m=2 nf=1
MM2<317> vss vdd_array vss vss nch_18ud12_mac l=800n w=800n m=2 nf=1
MM2<318> vss vdd_array vss vss nch_18ud12_mac l=800n w=800n m=2 nf=1
MM2<319> vss vdd_array vss vss nch_18ud12_mac l=800n w=800n m=2 nf=1
MM2<320> vss vdd_array vss vss nch_18ud12_mac l=800n w=800n m=2 nf=1
MM2<321> vss vdd_array vss vss nch_18ud12_mac l=800n w=800n m=2 nf=1
MM2<322> vss vdd_array vss vss nch_18ud12_mac l=800n w=800n m=2 nf=1
MM2<323> vss vdd_array vss vss nch_18ud12_mac l=800n w=800n m=2 nf=1
MM2<324> vss vdd_array vss vss nch_18ud12_mac l=800n w=800n m=2 nf=1
MM2<325> vss vdd_array vss vss nch_18ud12_mac l=800n w=800n m=2 nf=1
MM2<326> vss vdd_array vss vss nch_18ud12_mac l=800n w=800n m=2 nf=1
MM2<327> vss vdd_array vss vss nch_18ud12_mac l=800n w=800n m=2 nf=1
MM2<328> vss vdd_array vss vss nch_18ud12_mac l=800n w=800n m=2 nf=1
MM2<329> vss vdd_array vss vss nch_18ud12_mac l=800n w=800n m=2 nf=1
MM2<330> vss vdd_array vss vss nch_18ud12_mac l=800n w=800n m=2 nf=1
MM2<331> vss vdd_array vss vss nch_18ud12_mac l=800n w=800n m=2 nf=1
MM2<332> vss vdd_array vss vss nch_18ud12_mac l=800n w=800n m=2 nf=1
MM2<333> vss vdd_array vss vss nch_18ud12_mac l=800n w=800n m=2 nf=1
MM2<334> vss vdd_array vss vss nch_18ud12_mac l=800n w=800n m=2 nf=1
MM2<335> vss vdd_array vss vss nch_18ud12_mac l=800n w=800n m=2 nf=1
MM2<336> vss vdd_array vss vss nch_18ud12_mac l=800n w=800n m=2 nf=1
MM2<337> vss vdd_array vss vss nch_18ud12_mac l=800n w=800n m=2 nf=1
MM2<338> vss vdd_array vss vss nch_18ud12_mac l=800n w=800n m=2 nf=1
MM2<339> vss vdd_array vss vss nch_18ud12_mac l=800n w=800n m=2 nf=1
MM2<340> vss vdd_array vss vss nch_18ud12_mac l=800n w=800n m=2 nf=1
MM2<341> vss vdd_array vss vss nch_18ud12_mac l=800n w=800n m=2 nf=1
MM2<342> vss vdd_array vss vss nch_18ud12_mac l=800n w=800n m=2 nf=1
MM2<343> vss vdd_array vss vss nch_18ud12_mac l=800n w=800n m=2 nf=1
MM2<344> vss vdd_array vss vss nch_18ud12_mac l=800n w=800n m=2 nf=1
MM2<345> vss vdd_array vss vss nch_18ud12_mac l=800n w=800n m=2 nf=1
MM2<346> vss vdd_array vss vss nch_18ud12_mac l=800n w=800n m=2 nf=1
MM2<347> vss vdd_array vss vss nch_18ud12_mac l=800n w=800n m=2 nf=1
MM2<348> vss vdd_array vss vss nch_18ud12_mac l=800n w=800n m=2 nf=1
MM2<349> vss vdd_array vss vss nch_18ud12_mac l=800n w=800n m=2 nf=1
MM2<350> vss vdd_array vss vss nch_18ud12_mac l=800n w=800n m=2 nf=1
MM2<351> vss vdd_array vss vss nch_18ud12_mac l=800n w=800n m=2 nf=1
MM2<352> vss vdd_array vss vss nch_18ud12_mac l=800n w=800n m=2 nf=1
MM2<353> vss vdd_array vss vss nch_18ud12_mac l=800n w=800n m=2 nf=1
MM2<354> vss vdd_array vss vss nch_18ud12_mac l=800n w=800n m=2 nf=1
MM2<355> vss vdd_array vss vss nch_18ud12_mac l=800n w=800n m=2 nf=1
MM2<356> vss vdd_array vss vss nch_18ud12_mac l=800n w=800n m=2 nf=1
MM2<357> vss vdd_array vss vss nch_18ud12_mac l=800n w=800n m=2 nf=1
MM2<358> vss vdd_array vss vss nch_18ud12_mac l=800n w=800n m=2 nf=1
MM2<359> vss vdd_array vss vss nch_18ud12_mac l=800n w=800n m=2 nf=1
MM2<360> vss vdd_array vss vss nch_18ud12_mac l=800n w=800n m=2 nf=1
MM2<361> vss vdd_array vss vss nch_18ud12_mac l=800n w=800n m=2 nf=1
MM2<362> vss vdd_array vss vss nch_18ud12_mac l=800n w=800n m=2 nf=1
MM2<363> vss vdd_array vss vss nch_18ud12_mac l=800n w=800n m=2 nf=1
MM2<364> vss vdd_array vss vss nch_18ud12_mac l=800n w=800n m=2 nf=1
MM2<365> vss vdd_array vss vss nch_18ud12_mac l=800n w=800n m=2 nf=1
MM2<366> vss vdd_array vss vss nch_18ud12_mac l=800n w=800n m=2 nf=1
MM2<367> vss vdd_array vss vss nch_18ud12_mac l=800n w=800n m=2 nf=1
MM2<368> vss vdd_array vss vss nch_18ud12_mac l=800n w=800n m=2 nf=1
MM2<369> vss vdd_array vss vss nch_18ud12_mac l=800n w=800n m=2 nf=1
MM2<370> vss vdd_array vss vss nch_18ud12_mac l=800n w=800n m=2 nf=1
MM2<371> vss vdd_array vss vss nch_18ud12_mac l=800n w=800n m=2 nf=1
MM2<372> vss vdd_array vss vss nch_18ud12_mac l=800n w=800n m=2 nf=1
MM2<373> vss vdd_array vss vss nch_18ud12_mac l=800n w=800n m=2 nf=1
MM2<374> vss vdd_array vss vss nch_18ud12_mac l=800n w=800n m=2 nf=1
MM2<375> vss vdd_array vss vss nch_18ud12_mac l=800n w=800n m=2 nf=1
MM2<376> vss vdd_array vss vss nch_18ud12_mac l=800n w=800n m=2 nf=1
MM2<377> vss vdd_array vss vss nch_18ud12_mac l=800n w=800n m=2 nf=1
MM2<378> vss vdd_array vss vss nch_18ud12_mac l=800n w=800n m=2 nf=1
MM2<379> vss vdd_array vss vss nch_18ud12_mac l=800n w=800n m=2 nf=1
MM2<380> vss vdd_array vss vss nch_18ud12_mac l=800n w=800n m=2 nf=1
MM2<381> vss vdd_array vss vss nch_18ud12_mac l=800n w=800n m=2 nf=1
MM2<382> vss vdd_array vss vss nch_18ud12_mac l=800n w=800n m=2 nf=1
MM2<383> vss vdd_array vss vss nch_18ud12_mac l=800n w=800n m=2 nf=1
MM2<384> vss vdd_array vss vss nch_18ud12_mac l=800n w=800n m=2 nf=1
MM2<385> vss vdd_array vss vss nch_18ud12_mac l=800n w=800n m=2 nf=1
MM2<386> vss vdd_array vss vss nch_18ud12_mac l=800n w=800n m=2 nf=1
MM2<387> vss vdd_array vss vss nch_18ud12_mac l=800n w=800n m=2 nf=1
MM2<388> vss vdd_array vss vss nch_18ud12_mac l=800n w=800n m=2 nf=1
MM2<389> vss vdd_array vss vss nch_18ud12_mac l=800n w=800n m=2 nf=1
MM2<390> vss vdd_array vss vss nch_18ud12_mac l=800n w=800n m=2 nf=1
MM2<391> vss vdd_array vss vss nch_18ud12_mac l=800n w=800n m=2 nf=1
MM2<392> vss vdd_array vss vss nch_18ud12_mac l=800n w=800n m=2 nf=1
MM2<393> vss vdd_array vss vss nch_18ud12_mac l=800n w=800n m=2 nf=1
MM2<394> vss vdd_array vss vss nch_18ud12_mac l=800n w=800n m=2 nf=1
MM2<395> vss vdd_array vss vss nch_18ud12_mac l=800n w=800n m=2 nf=1
MM2<396> vss vdd_array vss vss nch_18ud12_mac l=800n w=800n m=2 nf=1
MM2<397> vss vdd_array vss vss nch_18ud12_mac l=800n w=800n m=2 nf=1
MM2<398> vss vdd_array vss vss nch_18ud12_mac l=800n w=800n m=2 nf=1
MM2<399> vss vdd_array vss vss nch_18ud12_mac l=800n w=800n m=2 nf=1
MM2<400> vss vdd_array vss vss nch_18ud12_mac l=800n w=800n m=2 nf=1
MM2<401> vss vdd_array vss vss nch_18ud12_mac l=800n w=800n m=2 nf=1
MM2<402> vss vdd_array vss vss nch_18ud12_mac l=800n w=800n m=2 nf=1
MM2<403> vss vdd_array vss vss nch_18ud12_mac l=800n w=800n m=2 nf=1
MM2<404> vss vdd_array vss vss nch_18ud12_mac l=800n w=800n m=2 nf=1
MM2<405> vss vdd_array vss vss nch_18ud12_mac l=800n w=800n m=2 nf=1
MM2<406> vss vdd_array vss vss nch_18ud12_mac l=800n w=800n m=2 nf=1
MM2<407> vss vdd_array vss vss nch_18ud12_mac l=800n w=800n m=2 nf=1
MM2<408> vss vdd_array vss vss nch_18ud12_mac l=800n w=800n m=2 nf=1
MM2<409> vss vdd_array vss vss nch_18ud12_mac l=800n w=800n m=2 nf=1
MM2<410> vss vdd_array vss vss nch_18ud12_mac l=800n w=800n m=2 nf=1
MM2<411> vss vdd_array vss vss nch_18ud12_mac l=800n w=800n m=2 nf=1
MM2<412> vss vdd_array vss vss nch_18ud12_mac l=800n w=800n m=2 nf=1
MM2<413> vss vdd_array vss vss nch_18ud12_mac l=800n w=800n m=2 nf=1
MM2<414> vss vdd_array vss vss nch_18ud12_mac l=800n w=800n m=2 nf=1
MM2<415> vss vdd_array vss vss nch_18ud12_mac l=800n w=800n m=2 nf=1
MM2<416> vss vdd_array vss vss nch_18ud12_mac l=800n w=800n m=2 nf=1
MM2<417> vss vdd_array vss vss nch_18ud12_mac l=800n w=800n m=2 nf=1
MM2<418> vss vdd_array vss vss nch_18ud12_mac l=800n w=800n m=2 nf=1
MM2<419> vss vdd_array vss vss nch_18ud12_mac l=800n w=800n m=2 nf=1
MM2<420> vss vdd_array vss vss nch_18ud12_mac l=800n w=800n m=2 nf=1
MM2<421> vss vdd_array vss vss nch_18ud12_mac l=800n w=800n m=2 nf=1
MM2<422> vss vdd_array vss vss nch_18ud12_mac l=800n w=800n m=2 nf=1
MM2<423> vss vdd_array vss vss nch_18ud12_mac l=800n w=800n m=2 nf=1
MM2<424> vss vdd_array vss vss nch_18ud12_mac l=800n w=800n m=2 nf=1
MM2<425> vss vdd_array vss vss nch_18ud12_mac l=800n w=800n m=2 nf=1
MM2<426> vss vdd_array vss vss nch_18ud12_mac l=800n w=800n m=2 nf=1
MM2<427> vss vdd_array vss vss nch_18ud12_mac l=800n w=800n m=2 nf=1
MM2<428> vss vdd_array vss vss nch_18ud12_mac l=800n w=800n m=2 nf=1
MM2<429> vss vdd_array vss vss nch_18ud12_mac l=800n w=800n m=2 nf=1
MM2<430> vss vdd_array vss vss nch_18ud12_mac l=800n w=800n m=2 nf=1
MM2<431> vss vdd_array vss vss nch_18ud12_mac l=800n w=800n m=2 nf=1
MM2<432> vss vdd_array vss vss nch_18ud12_mac l=800n w=800n m=2 nf=1
MM2<433> vss vdd_array vss vss nch_18ud12_mac l=800n w=800n m=2 nf=1
MM2<434> vss vdd_array vss vss nch_18ud12_mac l=800n w=800n m=2 nf=1
MM2<435> vss vdd_array vss vss nch_18ud12_mac l=800n w=800n m=2 nf=1
MM2<436> vss vdd_array vss vss nch_18ud12_mac l=800n w=800n m=2 nf=1
MM2<437> vss vdd_array vss vss nch_18ud12_mac l=800n w=800n m=2 nf=1
MM2<438> vss vdd_array vss vss nch_18ud12_mac l=800n w=800n m=2 nf=1
MM2<439> vss vdd_array vss vss nch_18ud12_mac l=800n w=800n m=2 nf=1
MM2<440> vss vdd_array vss vss nch_18ud12_mac l=800n w=800n m=2 nf=1
MM2<441> vss vdd_array vss vss nch_18ud12_mac l=800n w=800n m=2 nf=1
MM2<442> vss vdd_array vss vss nch_18ud12_mac l=800n w=800n m=2 nf=1
MM2<443> vss vdd_array vss vss nch_18ud12_mac l=800n w=800n m=2 nf=1
MM2<444> vss vdd_array vss vss nch_18ud12_mac l=800n w=800n m=2 nf=1
MM2<445> vss vdd_array vss vss nch_18ud12_mac l=800n w=800n m=2 nf=1
MM2<446> vss vdd_array vss vss nch_18ud12_mac l=800n w=800n m=2 nf=1
MM2<447> vss vdd_array vss vss nch_18ud12_mac l=800n w=800n m=2 nf=1
MM2<448> vss vdd_array vss vss nch_18ud12_mac l=800n w=800n m=2 nf=1
MM2<449> vss vdd_array vss vss nch_18ud12_mac l=800n w=800n m=2 nf=1
MM2<450> vss vdd_array vss vss nch_18ud12_mac l=800n w=800n m=2 nf=1
MM2<451> vss vdd_array vss vss nch_18ud12_mac l=800n w=800n m=2 nf=1
MM2<452> vss vdd_array vss vss nch_18ud12_mac l=800n w=800n m=2 nf=1
MM2<453> vss vdd_array vss vss nch_18ud12_mac l=800n w=800n m=2 nf=1
MM2<454> vss vdd_array vss vss nch_18ud12_mac l=800n w=800n m=2 nf=1
MM2<455> vss vdd_array vss vss nch_18ud12_mac l=800n w=800n m=2 nf=1
MM2<456> vss vdd_array vss vss nch_18ud12_mac l=800n w=800n m=2 nf=1
MM2<457> vss vdd_array vss vss nch_18ud12_mac l=800n w=800n m=2 nf=1
MM2<458> vss vdd_array vss vss nch_18ud12_mac l=800n w=800n m=2 nf=1
MM2<459> vss vdd_array vss vss nch_18ud12_mac l=800n w=800n m=2 nf=1
MM2<460> vss vdd_array vss vss nch_18ud12_mac l=800n w=800n m=2 nf=1
MM2<461> vss vdd_array vss vss nch_18ud12_mac l=800n w=800n m=2 nf=1
MM2<462> vss vdd_array vss vss nch_18ud12_mac l=800n w=800n m=2 nf=1
MM2<463> vss vdd_array vss vss nch_18ud12_mac l=800n w=800n m=2 nf=1
MM2<464> vss vdd_array vss vss nch_18ud12_mac l=800n w=800n m=2 nf=1
MM2<465> vss vdd_array vss vss nch_18ud12_mac l=800n w=800n m=2 nf=1
MM2<466> vss vdd_array vss vss nch_18ud12_mac l=800n w=800n m=2 nf=1
MM2<467> vss vdd_array vss vss nch_18ud12_mac l=800n w=800n m=2 nf=1
MM2<468> vss vdd_array vss vss nch_18ud12_mac l=800n w=800n m=2 nf=1
MM2<469> vss vdd_array vss vss nch_18ud12_mac l=800n w=800n m=2 nf=1
MM2<470> vss vdd_array vss vss nch_18ud12_mac l=800n w=800n m=2 nf=1
MM2<471> vss vdd_array vss vss nch_18ud12_mac l=800n w=800n m=2 nf=1
MM2<472> vss vdd_array vss vss nch_18ud12_mac l=800n w=800n m=2 nf=1
MM2<473> vss vdd_array vss vss nch_18ud12_mac l=800n w=800n m=2 nf=1
MM2<474> vss vdd_array vss vss nch_18ud12_mac l=800n w=800n m=2 nf=1
MM2<475> vss vdd_array vss vss nch_18ud12_mac l=800n w=800n m=2 nf=1
MM2<476> vss vdd_array vss vss nch_18ud12_mac l=800n w=800n m=2 nf=1
MM2<477> vss vdd_array vss vss nch_18ud12_mac l=800n w=800n m=2 nf=1
MM2<478> vss vdd_array vss vss nch_18ud12_mac l=800n w=800n m=2 nf=1
MM2<479> vss vdd_array vss vss nch_18ud12_mac l=800n w=800n m=2 nf=1
MM2<480> vss vdd_array vss vss nch_18ud12_mac l=800n w=800n m=2 nf=1
MM2<481> vss vdd_array vss vss nch_18ud12_mac l=800n w=800n m=2 nf=1
MM2<482> vss vdd_array vss vss nch_18ud12_mac l=800n w=800n m=2 nf=1
MM2<483> vss vdd_array vss vss nch_18ud12_mac l=800n w=800n m=2 nf=1
MM2<484> vss vdd_array vss vss nch_18ud12_mac l=800n w=800n m=2 nf=1
MM2<485> vss vdd_array vss vss nch_18ud12_mac l=800n w=800n m=2 nf=1
MM2<486> vss vdd_array vss vss nch_18ud12_mac l=800n w=800n m=2 nf=1
MM2<487> vss vdd_array vss vss nch_18ud12_mac l=800n w=800n m=2 nf=1
MM2<488> vss vdd_array vss vss nch_18ud12_mac l=800n w=800n m=2 nf=1
MM2<489> vss vdd_array vss vss nch_18ud12_mac l=800n w=800n m=2 nf=1
MM2<490> vss vdd_array vss vss nch_18ud12_mac l=800n w=800n m=2 nf=1
MM2<491> vss vdd_array vss vss nch_18ud12_mac l=800n w=800n m=2 nf=1
MM2<492> vss vdd_array vss vss nch_18ud12_mac l=800n w=800n m=2 nf=1
MM2<493> vss vdd_array vss vss nch_18ud12_mac l=800n w=800n m=2 nf=1
MM2<494> vss vdd_array vss vss nch_18ud12_mac l=800n w=800n m=2 nf=1
MM2<495> vss vdd_array vss vss nch_18ud12_mac l=800n w=800n m=2 nf=1
MM2<496> vss vdd_array vss vss nch_18ud12_mac l=800n w=800n m=2 nf=1
MM2<497> vss vdd_array vss vss nch_18ud12_mac l=800n w=800n m=2 nf=1
MM2<498> vss vdd_array vss vss nch_18ud12_mac l=800n w=800n m=2 nf=1
MM2<499> vss vdd_array vss vss nch_18ud12_mac l=800n w=800n m=2 nf=1
MM2<500> vss vdd_array vss vss nch_18ud12_mac l=800n w=800n m=2 nf=1
MM2<501> vss vdd_array vss vss nch_18ud12_mac l=800n w=800n m=2 nf=1
MM2<502> vss vdd_array vss vss nch_18ud12_mac l=800n w=800n m=2 nf=1
MM2<503> vss vdd_array vss vss nch_18ud12_mac l=800n w=800n m=2 nf=1
MM2<504> vss vdd_array vss vss nch_18ud12_mac l=800n w=800n m=2 nf=1
MM2<505> vss vdd_array vss vss nch_18ud12_mac l=800n w=800n m=2 nf=1
MM2<506> vss vdd_array vss vss nch_18ud12_mac l=800n w=800n m=2 nf=1
MM2<507> vss vdd_array vss vss nch_18ud12_mac l=800n w=800n m=2 nf=1
MM2<508> vss vdd_array vss vss nch_18ud12_mac l=800n w=800n m=2 nf=1
MM2<509> vss vdd_array vss vss nch_18ud12_mac l=800n w=800n m=2 nf=1
MM2<510> vss vdd_array vss vss nch_18ud12_mac l=800n w=800n m=2 nf=1
MM2<511> vss vdd_array vss vss nch_18ud12_mac l=800n w=800n m=2 nf=1
MM2<512> vss vdd_array vss vss nch_18ud12_mac l=800n w=800n m=2 nf=1
MM2<513> vss vdd_array vss vss nch_18ud12_mac l=800n w=800n m=2 nf=1
MM2<514> vss vdd_array vss vss nch_18ud12_mac l=800n w=800n m=2 nf=1
MM2<515> vss vdd_array vss vss nch_18ud12_mac l=800n w=800n m=2 nf=1
MM2<516> vss vdd_array vss vss nch_18ud12_mac l=800n w=800n m=2 nf=1
MM2<517> vss vdd_array vss vss nch_18ud12_mac l=800n w=800n m=2 nf=1
MM2<518> vss vdd_array vss vss nch_18ud12_mac l=800n w=800n m=2 nf=1
MM2<519> vss vdd_array vss vss nch_18ud12_mac l=800n w=800n m=2 nf=1
MM2<520> vss vdd_array vss vss nch_18ud12_mac l=800n w=800n m=2 nf=1
MM2<521> vss vdd_array vss vss nch_18ud12_mac l=800n w=800n m=2 nf=1
MM2<522> vss vdd_array vss vss nch_18ud12_mac l=800n w=800n m=2 nf=1
MM2<523> vss vdd_array vss vss nch_18ud12_mac l=800n w=800n m=2 nf=1
MM2<524> vss vdd_array vss vss nch_18ud12_mac l=800n w=800n m=2 nf=1
MM2<525> vss vdd_array vss vss nch_18ud12_mac l=800n w=800n m=2 nf=1
MM2<526> vss vdd_array vss vss nch_18ud12_mac l=800n w=800n m=2 nf=1
MM2<527> vss vdd_array vss vss nch_18ud12_mac l=800n w=800n m=2 nf=1
MM2<528> vss vdd_array vss vss nch_18ud12_mac l=800n w=800n m=2 nf=1
MM2<529> vss vdd_array vss vss nch_18ud12_mac l=800n w=800n m=2 nf=1
MM2<530> vss vdd_array vss vss nch_18ud12_mac l=800n w=800n m=2 nf=1
MM2<531> vss vdd_array vss vss nch_18ud12_mac l=800n w=800n m=2 nf=1
MM2<532> vss vdd_array vss vss nch_18ud12_mac l=800n w=800n m=2 nf=1
MM2<533> vss vdd_array vss vss nch_18ud12_mac l=800n w=800n m=2 nf=1
MM2<534> vss vdd_array vss vss nch_18ud12_mac l=800n w=800n m=2 nf=1
MM2<535> vss vdd_array vss vss nch_18ud12_mac l=800n w=800n m=2 nf=1
MM2<536> vss vdd_array vss vss nch_18ud12_mac l=800n w=800n m=2 nf=1
MM2<537> vss vdd_array vss vss nch_18ud12_mac l=800n w=800n m=2 nf=1
MM2<538> vss vdd_array vss vss nch_18ud12_mac l=800n w=800n m=2 nf=1
MM2<539> vss vdd_array vss vss nch_18ud12_mac l=800n w=800n m=2 nf=1
MM2<540> vss vdd_array vss vss nch_18ud12_mac l=800n w=800n m=2 nf=1
MM2<541> vss vdd_array vss vss nch_18ud12_mac l=800n w=800n m=2 nf=1
MM2<542> vss vdd_array vss vss nch_18ud12_mac l=800n w=800n m=2 nf=1
MM2<543> vss vdd_array vss vss nch_18ud12_mac l=800n w=800n m=2 nf=1
MM2<544> vss vdd_array vss vss nch_18ud12_mac l=800n w=800n m=2 nf=1
MM2<545> vss vdd_array vss vss nch_18ud12_mac l=800n w=800n m=2 nf=1
MM2<546> vss vdd_array vss vss nch_18ud12_mac l=800n w=800n m=2 nf=1
MM2<547> vss vdd_array vss vss nch_18ud12_mac l=800n w=800n m=2 nf=1
MM2<548> vss vdd_array vss vss nch_18ud12_mac l=800n w=800n m=2 nf=1
MM2<549> vss vdd_array vss vss nch_18ud12_mac l=800n w=800n m=2 nf=1
MM2<550> vss vdd_array vss vss nch_18ud12_mac l=800n w=800n m=2 nf=1
MM2<551> vss vdd_array vss vss nch_18ud12_mac l=800n w=800n m=2 nf=1
MM2<552> vss vdd_array vss vss nch_18ud12_mac l=800n w=800n m=2 nf=1
MM2<553> vss vdd_array vss vss nch_18ud12_mac l=800n w=800n m=2 nf=1
MM2<554> vss vdd_array vss vss nch_18ud12_mac l=800n w=800n m=2 nf=1
MM2<555> vss vdd_array vss vss nch_18ud12_mac l=800n w=800n m=2 nf=1
MM2<556> vss vdd_array vss vss nch_18ud12_mac l=800n w=800n m=2 nf=1
MM2<557> vss vdd_array vss vss nch_18ud12_mac l=800n w=800n m=2 nf=1
MM2<558> vss vdd_array vss vss nch_18ud12_mac l=800n w=800n m=2 nf=1
MM2<559> vss vdd_array vss vss nch_18ud12_mac l=800n w=800n m=2 nf=1
MM2<560> vss vdd_array vss vss nch_18ud12_mac l=800n w=800n m=2 nf=1
MM2<561> vss vdd_array vss vss nch_18ud12_mac l=800n w=800n m=2 nf=1
MM2<562> vss vdd_array vss vss nch_18ud12_mac l=800n w=800n m=2 nf=1
MM2<563> vss vdd_array vss vss nch_18ud12_mac l=800n w=800n m=2 nf=1
MM2<564> vss vdd_array vss vss nch_18ud12_mac l=800n w=800n m=2 nf=1
MM2<565> vss vdd_array vss vss nch_18ud12_mac l=800n w=800n m=2 nf=1
MM2<566> vss vdd_array vss vss nch_18ud12_mac l=800n w=800n m=2 nf=1
MM2<567> vss vdd_array vss vss nch_18ud12_mac l=800n w=800n m=2 nf=1
MM2<568> vss vdd_array vss vss nch_18ud12_mac l=800n w=800n m=2 nf=1
MM2<569> vss vdd_array vss vss nch_18ud12_mac l=800n w=800n m=2 nf=1
MM2<570> vss vdd_array vss vss nch_18ud12_mac l=800n w=800n m=2 nf=1
MM2<571> vss vdd_array vss vss nch_18ud12_mac l=800n w=800n m=2 nf=1
MM2<572> vss vdd_array vss vss nch_18ud12_mac l=800n w=800n m=2 nf=1
MM2<573> vss vdd_array vss vss nch_18ud12_mac l=800n w=800n m=2 nf=1
MM2<574> vss vdd_array vss vss nch_18ud12_mac l=800n w=800n m=2 nf=1
MM2<575> vss vdd_array vss vss nch_18ud12_mac l=800n w=800n m=2 nf=1
MM2<576> vss vdd_array vss vss nch_18ud12_mac l=800n w=800n m=2 nf=1
MM2<577> vss vdd_array vss vss nch_18ud12_mac l=800n w=800n m=2 nf=1
MM2<578> vss vdd_array vss vss nch_18ud12_mac l=800n w=800n m=2 nf=1
MM2<579> vss vdd_array vss vss nch_18ud12_mac l=800n w=800n m=2 nf=1
MM2<580> vss vdd_array vss vss nch_18ud12_mac l=800n w=800n m=2 nf=1
MM2<581> vss vdd_array vss vss nch_18ud12_mac l=800n w=800n m=2 nf=1
MM2<582> vss vdd_array vss vss nch_18ud12_mac l=800n w=800n m=2 nf=1
MM2<583> vss vdd_array vss vss nch_18ud12_mac l=800n w=800n m=2 nf=1
MM2<584> vss vdd_array vss vss nch_18ud12_mac l=800n w=800n m=2 nf=1
MM2<585> vss vdd_array vss vss nch_18ud12_mac l=800n w=800n m=2 nf=1
MM2<586> vss vdd_array vss vss nch_18ud12_mac l=800n w=800n m=2 nf=1
MM2<587> vss vdd_array vss vss nch_18ud12_mac l=800n w=800n m=2 nf=1
MM2<588> vss vdd_array vss vss nch_18ud12_mac l=800n w=800n m=2 nf=1
MM2<589> vss vdd_array vss vss nch_18ud12_mac l=800n w=800n m=2 nf=1
MM2<590> vss vdd_array vss vss nch_18ud12_mac l=800n w=800n m=2 nf=1
MM2<591> vss vdd_array vss vss nch_18ud12_mac l=800n w=800n m=2 nf=1
MM2<592> vss vdd_array vss vss nch_18ud12_mac l=800n w=800n m=2 nf=1
MM2<593> vss vdd_array vss vss nch_18ud12_mac l=800n w=800n m=2 nf=1
MM2<594> vss vdd_array vss vss nch_18ud12_mac l=800n w=800n m=2 nf=1
MM2<595> vss vdd_array vss vss nch_18ud12_mac l=800n w=800n m=2 nf=1
MM2<596> vss vdd_array vss vss nch_18ud12_mac l=800n w=800n m=2 nf=1
MM2<597> vss vdd_array vss vss nch_18ud12_mac l=800n w=800n m=2 nf=1
MM2<598> vss vdd_array vss vss nch_18ud12_mac l=800n w=800n m=2 nf=1
MM2<599> vss vdd_array vss vss nch_18ud12_mac l=800n w=800n m=2 nf=1
MM2<600> vss vdd_array vss vss nch_18ud12_mac l=800n w=800n m=2 nf=1
MM2<601> vss vdd_array vss vss nch_18ud12_mac l=800n w=800n m=2 nf=1
MM2<602> vss vdd_array vss vss nch_18ud12_mac l=800n w=800n m=2 nf=1
MM2<603> vss vdd_array vss vss nch_18ud12_mac l=800n w=800n m=2 nf=1
MM2<604> vss vdd_array vss vss nch_18ud12_mac l=800n w=800n m=2 nf=1
MM2<605> vss vdd_array vss vss nch_18ud12_mac l=800n w=800n m=2 nf=1
MM2<606> vss vdd_array vss vss nch_18ud12_mac l=800n w=800n m=2 nf=1
MM2<607> vss vdd_array vss vss nch_18ud12_mac l=800n w=800n m=2 nf=1
MM2<608> vss vdd_array vss vss nch_18ud12_mac l=800n w=800n m=2 nf=1
MM2<609> vss vdd_array vss vss nch_18ud12_mac l=800n w=800n m=2 nf=1
MM2<610> vss vdd_array vss vss nch_18ud12_mac l=800n w=800n m=2 nf=1
MM2<611> vss vdd_array vss vss nch_18ud12_mac l=800n w=800n m=2 nf=1
MM2<612> vss vdd_array vss vss nch_18ud12_mac l=800n w=800n m=2 nf=1
MM2<613> vss vdd_array vss vss nch_18ud12_mac l=800n w=800n m=2 nf=1
MM2<614> vss vdd_array vss vss nch_18ud12_mac l=800n w=800n m=2 nf=1
MM2<615> vss vdd_array vss vss nch_18ud12_mac l=800n w=800n m=2 nf=1
MM2<616> vss vdd_array vss vss nch_18ud12_mac l=800n w=800n m=2 nf=1
MM2<617> vss vdd_array vss vss nch_18ud12_mac l=800n w=800n m=2 nf=1
MM2<618> vss vdd_array vss vss nch_18ud12_mac l=800n w=800n m=2 nf=1
MM2<619> vss vdd_array vss vss nch_18ud12_mac l=800n w=800n m=2 nf=1
MM2<620> vss vdd_array vss vss nch_18ud12_mac l=800n w=800n m=2 nf=1
MM2<621> vss vdd_array vss vss nch_18ud12_mac l=800n w=800n m=2 nf=1
MM2<622> vss vdd_array vss vss nch_18ud12_mac l=800n w=800n m=2 nf=1
MM2<623> vss vdd_array vss vss nch_18ud12_mac l=800n w=800n m=2 nf=1
MM2<624> vss vdd_array vss vss nch_18ud12_mac l=800n w=800n m=2 nf=1
MM2<625> vss vdd_array vss vss nch_18ud12_mac l=800n w=800n m=2 nf=1
MM2<626> vss vdd_array vss vss nch_18ud12_mac l=800n w=800n m=2 nf=1
MM2<627> vss vdd_array vss vss nch_18ud12_mac l=800n w=800n m=2 nf=1
MM2<628> vss vdd_array vss vss nch_18ud12_mac l=800n w=800n m=2 nf=1
MM2<629> vss vdd_array vss vss nch_18ud12_mac l=800n w=800n m=2 nf=1
MM2<630> vss vdd_array vss vss nch_18ud12_mac l=800n w=800n m=2 nf=1
MM2<631> vss vdd_array vss vss nch_18ud12_mac l=800n w=800n m=2 nf=1
MM2<632> vss vdd_array vss vss nch_18ud12_mac l=800n w=800n m=2 nf=1
MM2<633> vss vdd_array vss vss nch_18ud12_mac l=800n w=800n m=2 nf=1
MM2<634> vss vdd_array vss vss nch_18ud12_mac l=800n w=800n m=2 nf=1
MM2<635> vss vdd_array vss vss nch_18ud12_mac l=800n w=800n m=2 nf=1
MM2<636> vss vdd_array vss vss nch_18ud12_mac l=800n w=800n m=2 nf=1
MM2<637> vss vdd_array vss vss nch_18ud12_mac l=800n w=800n m=2 nf=1
MM2<638> vss vdd_array vss vss nch_18ud12_mac l=800n w=800n m=2 nf=1
MM2<639> vss vdd_array vss vss nch_18ud12_mac l=800n w=800n m=2 nf=1
MM2<640> vss vdd_array vss vss nch_18ud12_mac l=800n w=800n m=2 nf=1
MM2<641> vss vdd_array vss vss nch_18ud12_mac l=800n w=800n m=2 nf=1
MM2<642> vss vdd_array vss vss nch_18ud12_mac l=800n w=800n m=2 nf=1
MM2<643> vss vdd_array vss vss nch_18ud12_mac l=800n w=800n m=2 nf=1
MM2<644> vss vdd_array vss vss nch_18ud12_mac l=800n w=800n m=2 nf=1
MM2<645> vss vdd_array vss vss nch_18ud12_mac l=800n w=800n m=2 nf=1
MM2<646> vss vdd_array vss vss nch_18ud12_mac l=800n w=800n m=2 nf=1
MM2<647> vss vdd_array vss vss nch_18ud12_mac l=800n w=800n m=2 nf=1
MM2<648> vss vdd_array vss vss nch_18ud12_mac l=800n w=800n m=2 nf=1
MM2<649> vss vdd_array vss vss nch_18ud12_mac l=800n w=800n m=2 nf=1
MM2<650> vss vdd_array vss vss nch_18ud12_mac l=800n w=800n m=2 nf=1
MM2<651> vss vdd_array vss vss nch_18ud12_mac l=800n w=800n m=2 nf=1
MM2<652> vss vdd_array vss vss nch_18ud12_mac l=800n w=800n m=2 nf=1
MM2<653> vss vdd_array vss vss nch_18ud12_mac l=800n w=800n m=2 nf=1
MM2<654> vss vdd_array vss vss nch_18ud12_mac l=800n w=800n m=2 nf=1
MM2<655> vss vdd_array vss vss nch_18ud12_mac l=800n w=800n m=2 nf=1
MM2<656> vss vdd_array vss vss nch_18ud12_mac l=800n w=800n m=2 nf=1
MM2<657> vss vdd_array vss vss nch_18ud12_mac l=800n w=800n m=2 nf=1
MM2<658> vss vdd_array vss vss nch_18ud12_mac l=800n w=800n m=2 nf=1
MM2<659> vss vdd_array vss vss nch_18ud12_mac l=800n w=800n m=2 nf=1
MM2<660> vss vdd_array vss vss nch_18ud12_mac l=800n w=800n m=2 nf=1
MM2<661> vss vdd_array vss vss nch_18ud12_mac l=800n w=800n m=2 nf=1
MM2<662> vss vdd_array vss vss nch_18ud12_mac l=800n w=800n m=2 nf=1
MM2<663> vss vdd_array vss vss nch_18ud12_mac l=800n w=800n m=2 nf=1
MM2<664> vss vdd_array vss vss nch_18ud12_mac l=800n w=800n m=2 nf=1
MM2<665> vss vdd_array vss vss nch_18ud12_mac l=800n w=800n m=2 nf=1
MM2<666> vss vdd_array vss vss nch_18ud12_mac l=800n w=800n m=2 nf=1
MM2<667> vss vdd_array vss vss nch_18ud12_mac l=800n w=800n m=2 nf=1
MM2<668> vss vdd_array vss vss nch_18ud12_mac l=800n w=800n m=2 nf=1
MM2<669> vss vdd_array vss vss nch_18ud12_mac l=800n w=800n m=2 nf=1
MM2<670> vss vdd_array vss vss nch_18ud12_mac l=800n w=800n m=2 nf=1
MM2<671> vss vdd_array vss vss nch_18ud12_mac l=800n w=800n m=2 nf=1
MM2<672> vss vdd_array vss vss nch_18ud12_mac l=800n w=800n m=2 nf=1
MM2<673> vss vdd_array vss vss nch_18ud12_mac l=800n w=800n m=2 nf=1
MM2<674> vss vdd_array vss vss nch_18ud12_mac l=800n w=800n m=2 nf=1
Xi350 clk_gcas_wr gcas_wr_ff_1 net46 vdd vss / NmCKGX2
Xgcas_wr_ckg clk_gcas_wr gcas_wr_ff_0 net483 vdd vss / NmCKGX2
Xi337 clk_gcas_rd gcas_rd_ff_1 net21 vdd vss / NmCKGX2
Xgcas_rd_ckg clk_gcas_rd gcas_rd_ff_0 net481 vdd vss / NmCKGX2
Xi354 net36[1] net36[0] net44 net43 net42 net41 net40 net39 net38 net37 vdd
+ vss / hb_macro_dly_dec
Xi322 net13[1] net13[0] net11 net10 net9 net12 net7 net6 net5 net4 vdd vss /
+ hb_macro_dly_dec
Xgcas_rd_dly_dec net510[1] net510[0] net463 net458 net453 net459 net460 net461
+ net457 net462 vdd vss / hb_macro_dly_dec
Xi76 net512[1] net512[0] net464 net469 net471 net468 net467 net466 net470
+ net465 vdd vss / hb_macro_dly_dec
XI37 net509[1] net509[0] net447 net446 net445 net444 net443 net442 net441
+ net440 vdd vss / hb_macro_dly_dec
Xgcadd_wr_dly_dec net508[1] net508[0] sel_0_wr sel_0_n_wr sel_1_wr sel_1_n_wr
+ sel_2_wr sel_2_n_wr sel_3_wr sel_3_n_wr vdd vss / hb_macro_dly_dec
Xi342 net33[1] net33[0] net31 net30 net29 net32 net26 net25 net24 net23 vdd
+ vss / hb_macro_dly_dec
Xi376<3> vdd vss net58 / TIELBWP7T30P140
Xi376<2> vdd vss net58 / TIELBWP7T30P140
Xi376<1> vdd vss net58 / TIELBWP7T30P140
Xi376<0> vdd vss net58 / TIELBWP7T30P140
Xi377<3> vdd vss net63 / TIELBWP7T30P140
Xi377<2> vdd vss net63 / TIELBWP7T30P140
Xi377<1> vdd vss net63 / TIELBWP7T30P140
Xi377<0> vdd vss net63 / TIELBWP7T30P140
Xi351 vdd vss net45 / TIELBWP7T30P140
Xi326 vdd vss net18 / TIELBWP7T30P140
Xi118 vdd vss net1 / TIELBWP7T30P140
Xi142 vdd vss net56 / TIELBWP7T30P140
Xi152 vdd vss net0133 / TIELBWP7T30P140
Xi339 vdd vss net20 / TIELBWP7T30P140
Xi155 vdd vss net0151 / TIELBWP7T30P140
Xi237 clk_asic_out_en vdd vss net379 / BUFFD12BWP7T30P140
Xi323 vdd_array vss cc_bnksel_n_d0_dly_1 bnksel_n_array_1 vdd vss /
+ Levelshift_1p1buf_large
Xlv_bnksel_n vdd_array vss cc_bnksel_n_d0_dly_0 bnksel_n_array_0 vdd vss /
+ Levelshift_1p1buf_large
Xlv_reset_n vdd_array vss reset_n_asic reset_n_array vdd vss /
+ Levelshift_1p1buf_large
Xasic_out_gradd_n_u<12> vdd_array vss gradd_ff[12] gradd_array[12] vdd vss /
+ Levelshift_1p1buf_large
Xasic_out_gradd_n_u<11> vdd_array vss gradd_ff[11] gradd_array[11] vdd vss /
+ Levelshift_1p1buf_large
Xasic_out_gradd_n_u<10> vdd_array vss gradd_ff[10] gradd_array[10] vdd vss /
+ Levelshift_1p1buf_large
Xasic_out_gradd_n_u<9> vdd_array vss gradd_ff[9] gradd_array[9] vdd vss /
+ Levelshift_1p1buf_large
Xasic_out_gradd_n_u<8> vdd_array vss gradd_ff[8] gradd_array[8] vdd vss /
+ Levelshift_1p1buf_large
Xasic_out_gradd_n_u<7> vdd_array vss gradd_ff[7] gradd_array[7] vdd vss /
+ Levelshift_1p1buf_large
Xasic_out_gradd_n_u<6> vdd_array vss gradd_ff[6] gradd_array[6] vdd vss /
+ Levelshift_1p1buf_large
Xasic_out_gradd_n_u<5> vdd_array vss gradd_ff[5] gradd_array[5] vdd vss /
+ Levelshift_1p1buf_large
Xasic_out_gradd_n_u<4> vdd_array vss gradd_ff[4] gradd_array[4] vdd vss /
+ Levelshift_1p1buf_large
Xasic_out_gradd_n_u<3> vdd_array vss gradd_ff[3] gradd_array[3] vdd vss /
+ Levelshift_1p1buf_large
Xasic_out_gradd_n_u<2> vdd_array vss gradd_ff[2] gradd_array[2] vdd vss /
+ Levelshift_1p1buf_large
Xasic_out_gradd_n_u<1> vdd_array vss gradd_ff[1] gradd_array[1] vdd vss /
+ Levelshift_1p1buf_large
Xasic_out_gradd_n_u<0> vdd_array vss gradd_ff[0] gradd_array[0] vdd vss /
+ Levelshift_1p1buf_large
Xi320 rdrdy_n_array_1 vdd_array vss / hb_diode
Xi81 rdrdy_n_array_0 vdd_array vss / hb_diode
Xwdata_reg10<16> ls_en_drv4[2] clk10 wdata_asic[101] wdata_ff[101] vdd vss /
+ DFCNQD1BWP7T30P140
Xwdata_reg10<15> ls_en_drv4[2] clk10 wdata_asic[100] wdata_ff[100] vdd vss /
+ DFCNQD1BWP7T30P140
Xwdata_reg10<14> ls_en_drv4[2] clk10 wdata_asic[99] wdata_ff[99] vdd vss /
+ DFCNQD1BWP7T30P140
Xwdata_reg10<13> ls_en_drv4[2] clk10 wdata_asic[98] wdata_ff[98] vdd vss /
+ DFCNQD1BWP7T30P140
Xwdata_reg10<12> ls_en_drv4[2] clk10 wdata_asic[97] wdata_ff[97] vdd vss /
+ DFCNQD1BWP7T30P140
Xwdata_reg10<11> ls_en_drv4[2] clk10 wdata_asic[96] wdata_ff[96] vdd vss /
+ DFCNQD1BWP7T30P140
Xwdata_reg10<10> ls_en_drv4[2] clk10 wdata_asic[95] wdata_ff[95] vdd vss /
+ DFCNQD1BWP7T30P140
Xwdata_reg10<9> ls_en_drv4[2] clk10 wdata_asic[94] wdata_ff[94] vdd vss /
+ DFCNQD1BWP7T30P140
Xwdata_reg10<8> ls_en_drv4[2] clk10 wdata_asic[93] wdata_ff[93] vdd vss /
+ DFCNQD1BWP7T30P140
Xwdata_reg10<7> ls_en_drv4[2] clk10 wdata_asic[92] wdata_ff[92] vdd vss /
+ DFCNQD1BWP7T30P140
Xwdata_reg10<6> ls_en_drv4[2] clk10 wdata_asic[91] wdata_ff[91] vdd vss /
+ DFCNQD1BWP7T30P140
Xwdata_reg10<5> ls_en_drv4[2] clk10 wdata_asic[90] wdata_ff[90] vdd vss /
+ DFCNQD1BWP7T30P140
Xwdata_reg10<4> ls_en_drv4[2] clk10 wdata_asic[89] wdata_ff[89] vdd vss /
+ DFCNQD1BWP7T30P140
Xwdata_reg10<3> ls_en_drv4[2] clk10 wdata_asic[88] wdata_ff[88] vdd vss /
+ DFCNQD1BWP7T30P140
Xwdata_reg10<2> ls_en_drv4[2] clk10 wdata_asic[87] wdata_ff[87] vdd vss /
+ DFCNQD1BWP7T30P140
Xwdata_reg10<1> ls_en_drv4[2] clk10 wdata_asic[86] wdata_ff[86] vdd vss /
+ DFCNQD1BWP7T30P140
Xwdata_reg10<0> ls_en_drv4[2] clk10 wdata_asic[85] wdata_ff[85] vdd vss /
+ DFCNQD1BWP7T30P140
Xwdata_reg8<16> ls_en_drv4[2] clk8 wdata_asic[33] wdata_ff[33] vdd vss /
+ DFCNQD1BWP7T30P140
Xwdata_reg8<15> ls_en_drv4[2] clk8 wdata_asic[32] wdata_ff[32] vdd vss /
+ DFCNQD1BWP7T30P140
Xwdata_reg8<14> ls_en_drv4[2] clk8 wdata_asic[31] wdata_ff[31] vdd vss /
+ DFCNQD1BWP7T30P140
Xwdata_reg8<13> ls_en_drv4[2] clk8 wdata_asic[30] wdata_ff[30] vdd vss /
+ DFCNQD1BWP7T30P140
Xwdata_reg8<12> ls_en_drv4[2] clk8 wdata_asic[29] wdata_ff[29] vdd vss /
+ DFCNQD1BWP7T30P140
Xwdata_reg8<11> ls_en_drv4[2] clk8 wdata_asic[28] wdata_ff[28] vdd vss /
+ DFCNQD1BWP7T30P140
Xwdata_reg8<10> ls_en_drv4[2] clk8 wdata_asic[27] wdata_ff[27] vdd vss /
+ DFCNQD1BWP7T30P140
Xwdata_reg8<9> ls_en_drv4[2] clk8 wdata_asic[26] wdata_ff[26] vdd vss /
+ DFCNQD1BWP7T30P140
Xwdata_reg8<8> ls_en_drv4[2] clk8 wdata_asic[25] wdata_ff[25] vdd vss /
+ DFCNQD1BWP7T30P140
Xwdata_reg8<7> ls_en_drv4[2] clk8 wdata_asic[24] wdata_ff[24] vdd vss /
+ DFCNQD1BWP7T30P140
Xwdata_reg8<6> ls_en_drv4[2] clk8 wdata_asic[23] wdata_ff[23] vdd vss /
+ DFCNQD1BWP7T30P140
Xwdata_reg8<5> ls_en_drv4[2] clk8 wdata_asic[22] wdata_ff[22] vdd vss /
+ DFCNQD1BWP7T30P140
Xwdata_reg8<4> ls_en_drv4[2] clk8 wdata_asic[21] wdata_ff[21] vdd vss /
+ DFCNQD1BWP7T30P140
Xwdata_reg8<3> ls_en_drv4[2] clk8 wdata_asic[20] wdata_ff[20] vdd vss /
+ DFCNQD1BWP7T30P140
Xwdata_reg8<2> ls_en_drv4[2] clk8 wdata_asic[19] wdata_ff[19] vdd vss /
+ DFCNQD1BWP7T30P140
Xwdata_reg8<1> ls_en_drv4[2] clk8 wdata_asic[18] wdata_ff[18] vdd vss /
+ DFCNQD1BWP7T30P140
Xwdata_reg8<0> ls_en_drv4[2] clk8 wdata_asic[17] wdata_ff[17] vdd vss /
+ DFCNQD1BWP7T30P140
Xwdata_reg15<16> ls_en_drv4[3] clk15 wdata_asic[271] wdata_ff[271] vdd vss /
+ DFCNQD1BWP7T30P140
Xwdata_reg15<15> ls_en_drv4[3] clk15 wdata_asic[270] wdata_ff[270] vdd vss /
+ DFCNQD1BWP7T30P140
Xwdata_reg15<14> ls_en_drv4[3] clk15 wdata_asic[269] wdata_ff[269] vdd vss /
+ DFCNQD1BWP7T30P140
Xwdata_reg15<13> ls_en_drv4[3] clk15 wdata_asic[268] wdata_ff[268] vdd vss /
+ DFCNQD1BWP7T30P140
Xwdata_reg15<12> ls_en_drv4[3] clk15 wdata_asic[267] wdata_ff[267] vdd vss /
+ DFCNQD1BWP7T30P140
Xwdata_reg15<11> ls_en_drv4[3] clk15 wdata_asic[266] wdata_ff[266] vdd vss /
+ DFCNQD1BWP7T30P140
Xwdata_reg15<10> ls_en_drv4[3] clk15 wdata_asic[265] wdata_ff[265] vdd vss /
+ DFCNQD1BWP7T30P140
Xwdata_reg15<9> ls_en_drv4[3] clk15 wdata_asic[264] wdata_ff[264] vdd vss /
+ DFCNQD1BWP7T30P140
Xwdata_reg15<8> ls_en_drv4[3] clk15 wdata_asic[263] wdata_ff[263] vdd vss /
+ DFCNQD1BWP7T30P140
Xwdata_reg15<7> ls_en_drv4[3] clk15 wdata_asic[262] wdata_ff[262] vdd vss /
+ DFCNQD1BWP7T30P140
Xwdata_reg15<6> ls_en_drv4[3] clk15 wdata_asic[261] wdata_ff[261] vdd vss /
+ DFCNQD1BWP7T30P140
Xwdata_reg15<5> ls_en_drv4[3] clk15 wdata_asic[260] wdata_ff[260] vdd vss /
+ DFCNQD1BWP7T30P140
Xwdata_reg15<4> ls_en_drv4[3] clk15 wdata_asic[259] wdata_ff[259] vdd vss /
+ DFCNQD1BWP7T30P140
Xwdata_reg15<3> ls_en_drv4[3] clk15 wdata_asic[258] wdata_ff[258] vdd vss /
+ DFCNQD1BWP7T30P140
Xwdata_reg15<2> ls_en_drv4[3] clk15 wdata_asic[257] wdata_ff[257] vdd vss /
+ DFCNQD1BWP7T30P140
Xwdata_reg15<1> ls_en_drv4[3] clk15 wdata_asic[256] wdata_ff[256] vdd vss /
+ DFCNQD1BWP7T30P140
Xwdata_reg15<0> ls_en_drv4[3] clk15 wdata_asic[255] wdata_ff[255] vdd vss /
+ DFCNQD1BWP7T30P140
Xwdata_reg6<16> ls_en_drv4[0] clk6 wdata_asic[220] wdata_ff[220] vdd vss /
+ DFCNQD1BWP7T30P140
Xwdata_reg6<15> ls_en_drv4[0] clk6 wdata_asic[219] wdata_ff[219] vdd vss /
+ DFCNQD1BWP7T30P140
Xwdata_reg6<14> ls_en_drv4[0] clk6 wdata_asic[218] wdata_ff[218] vdd vss /
+ DFCNQD1BWP7T30P140
Xwdata_reg6<13> ls_en_drv4[0] clk6 wdata_asic[217] wdata_ff[217] vdd vss /
+ DFCNQD1BWP7T30P140
Xwdata_reg6<12> ls_en_drv4[0] clk6 wdata_asic[216] wdata_ff[216] vdd vss /
+ DFCNQD1BWP7T30P140
Xwdata_reg6<11> ls_en_drv4[0] clk6 wdata_asic[215] wdata_ff[215] vdd vss /
+ DFCNQD1BWP7T30P140
Xwdata_reg6<10> ls_en_drv4[0] clk6 wdata_asic[214] wdata_ff[214] vdd vss /
+ DFCNQD1BWP7T30P140
Xwdata_reg6<9> ls_en_drv4[0] clk6 wdata_asic[213] wdata_ff[213] vdd vss /
+ DFCNQD1BWP7T30P140
Xwdata_reg6<8> ls_en_drv4[0] clk6 wdata_asic[212] wdata_ff[212] vdd vss /
+ DFCNQD1BWP7T30P140
Xwdata_reg6<7> ls_en_drv4[0] clk6 wdata_asic[211] wdata_ff[211] vdd vss /
+ DFCNQD1BWP7T30P140
Xwdata_reg6<6> ls_en_drv4[0] clk6 wdata_asic[210] wdata_ff[210] vdd vss /
+ DFCNQD1BWP7T30P140
Xwdata_reg6<5> ls_en_drv4[0] clk6 wdata_asic[209] wdata_ff[209] vdd vss /
+ DFCNQD1BWP7T30P140
Xwdata_reg6<4> ls_en_drv4[0] clk6 wdata_asic[208] wdata_ff[208] vdd vss /
+ DFCNQD1BWP7T30P140
Xwdata_reg6<3> ls_en_drv4[0] clk6 wdata_asic[207] wdata_ff[207] vdd vss /
+ DFCNQD1BWP7T30P140
Xwdata_reg6<2> ls_en_drv4[0] clk6 wdata_asic[206] wdata_ff[206] vdd vss /
+ DFCNQD1BWP7T30P140
Xwdata_reg6<1> ls_en_drv4[0] clk6 wdata_asic[205] wdata_ff[205] vdd vss /
+ DFCNQD1BWP7T30P140
Xwdata_reg6<0> ls_en_drv4[0] clk6 wdata_asic[204] wdata_ff[204] vdd vss /
+ DFCNQD1BWP7T30P140
Xwdata_reg3<16> ls_en_drv4[1] clk3 wdata_asic[118] wdata_ff[118] vdd vss /
+ DFCNQD1BWP7T30P140
Xwdata_reg3<15> ls_en_drv4[1] clk3 wdata_asic[117] wdata_ff[117] vdd vss /
+ DFCNQD1BWP7T30P140
Xwdata_reg3<14> ls_en_drv4[1] clk3 wdata_asic[116] wdata_ff[116] vdd vss /
+ DFCNQD1BWP7T30P140
Xwdata_reg3<13> ls_en_drv4[1] clk3 wdata_asic[115] wdata_ff[115] vdd vss /
+ DFCNQD1BWP7T30P140
Xwdata_reg3<12> ls_en_drv4[1] clk3 wdata_asic[114] wdata_ff[114] vdd vss /
+ DFCNQD1BWP7T30P140
Xwdata_reg3<11> ls_en_drv4[1] clk3 wdata_asic[113] wdata_ff[113] vdd vss /
+ DFCNQD1BWP7T30P140
Xwdata_reg3<10> ls_en_drv4[1] clk3 wdata_asic[112] wdata_ff[112] vdd vss /
+ DFCNQD1BWP7T30P140
Xwdata_reg3<9> ls_en_drv4[1] clk3 wdata_asic[111] wdata_ff[111] vdd vss /
+ DFCNQD1BWP7T30P140
Xwdata_reg3<8> ls_en_drv4[1] clk3 wdata_asic[110] wdata_ff[110] vdd vss /
+ DFCNQD1BWP7T30P140
Xwdata_reg3<7> ls_en_drv4[1] clk3 wdata_asic[109] wdata_ff[109] vdd vss /
+ DFCNQD1BWP7T30P140
Xwdata_reg3<6> ls_en_drv4[1] clk3 wdata_asic[108] wdata_ff[108] vdd vss /
+ DFCNQD1BWP7T30P140
Xwdata_reg3<5> ls_en_drv4[1] clk3 wdata_asic[107] wdata_ff[107] vdd vss /
+ DFCNQD1BWP7T30P140
Xwdata_reg3<4> ls_en_drv4[1] clk3 wdata_asic[106] wdata_ff[106] vdd vss /
+ DFCNQD1BWP7T30P140
Xwdata_reg3<3> ls_en_drv4[1] clk3 wdata_asic[105] wdata_ff[105] vdd vss /
+ DFCNQD1BWP7T30P140
Xwdata_reg3<2> ls_en_drv4[1] clk3 wdata_asic[104] wdata_ff[104] vdd vss /
+ DFCNQD1BWP7T30P140
Xwdata_reg3<1> ls_en_drv4[1] clk3 wdata_asic[103] wdata_ff[103] vdd vss /
+ DFCNQD1BWP7T30P140
Xwdata_reg3<0> ls_en_drv4[1] clk3 wdata_asic[102] wdata_ff[102] vdd vss /
+ DFCNQD1BWP7T30P140
Xwdata_reg7<16> ls_en_drv4[0] clk7 wdata_asic[254] wdata_ff[254] vdd vss /
+ DFCNQD1BWP7T30P140
Xwdata_reg7<15> ls_en_drv4[0] clk7 wdata_asic[253] wdata_ff[253] vdd vss /
+ DFCNQD1BWP7T30P140
Xwdata_reg7<14> ls_en_drv4[0] clk7 wdata_asic[252] wdata_ff[252] vdd vss /
+ DFCNQD1BWP7T30P140
Xwdata_reg7<13> ls_en_drv4[0] clk7 wdata_asic[251] wdata_ff[251] vdd vss /
+ DFCNQD1BWP7T30P140
Xwdata_reg7<12> ls_en_drv4[0] clk7 wdata_asic[250] wdata_ff[250] vdd vss /
+ DFCNQD1BWP7T30P140
Xwdata_reg7<11> ls_en_drv4[0] clk7 wdata_asic[249] wdata_ff[249] vdd vss /
+ DFCNQD1BWP7T30P140
Xwdata_reg7<10> ls_en_drv4[0] clk7 wdata_asic[248] wdata_ff[248] vdd vss /
+ DFCNQD1BWP7T30P140
Xwdata_reg7<9> ls_en_drv4[0] clk7 wdata_asic[247] wdata_ff[247] vdd vss /
+ DFCNQD1BWP7T30P140
Xwdata_reg7<8> ls_en_drv4[0] clk7 wdata_asic[246] wdata_ff[246] vdd vss /
+ DFCNQD1BWP7T30P140
Xwdata_reg7<7> ls_en_drv4[0] clk7 wdata_asic[245] wdata_ff[245] vdd vss /
+ DFCNQD1BWP7T30P140
Xwdata_reg7<6> ls_en_drv4[0] clk7 wdata_asic[244] wdata_ff[244] vdd vss /
+ DFCNQD1BWP7T30P140
Xwdata_reg7<5> ls_en_drv4[0] clk7 wdata_asic[243] wdata_ff[243] vdd vss /
+ DFCNQD1BWP7T30P140
Xwdata_reg7<4> ls_en_drv4[0] clk7 wdata_asic[242] wdata_ff[242] vdd vss /
+ DFCNQD1BWP7T30P140
Xwdata_reg7<3> ls_en_drv4[0] clk7 wdata_asic[241] wdata_ff[241] vdd vss /
+ DFCNQD1BWP7T30P140
Xwdata_reg7<2> ls_en_drv4[0] clk7 wdata_asic[240] wdata_ff[240] vdd vss /
+ DFCNQD1BWP7T30P140
Xwdata_reg7<1> ls_en_drv4[0] clk7 wdata_asic[239] wdata_ff[239] vdd vss /
+ DFCNQD1BWP7T30P140
Xwdata_reg7<0> ls_en_drv4[0] clk7 wdata_asic[238] wdata_ff[238] vdd vss /
+ DFCNQD1BWP7T30P140
Xwdata_reg1<16> ls_en_drv4[1] clk1 wdata_asic[50] wdata_ff[50] vdd vss /
+ DFCNQD1BWP7T30P140
Xwdata_reg1<15> ls_en_drv4[1] clk1 wdata_asic[49] wdata_ff[49] vdd vss /
+ DFCNQD1BWP7T30P140
Xwdata_reg1<14> ls_en_drv4[1] clk1 wdata_asic[48] wdata_ff[48] vdd vss /
+ DFCNQD1BWP7T30P140
Xwdata_reg1<13> ls_en_drv4[1] clk1 wdata_asic[47] wdata_ff[47] vdd vss /
+ DFCNQD1BWP7T30P140
Xwdata_reg1<12> ls_en_drv4[1] clk1 wdata_asic[46] wdata_ff[46] vdd vss /
+ DFCNQD1BWP7T30P140
Xwdata_reg1<11> ls_en_drv4[1] clk1 wdata_asic[45] wdata_ff[45] vdd vss /
+ DFCNQD1BWP7T30P140
Xwdata_reg1<10> ls_en_drv4[1] clk1 wdata_asic[44] wdata_ff[44] vdd vss /
+ DFCNQD1BWP7T30P140
Xwdata_reg1<9> ls_en_drv4[1] clk1 wdata_asic[43] wdata_ff[43] vdd vss /
+ DFCNQD1BWP7T30P140
Xwdata_reg1<8> ls_en_drv4[1] clk1 wdata_asic[42] wdata_ff[42] vdd vss /
+ DFCNQD1BWP7T30P140
Xwdata_reg1<7> ls_en_drv4[1] clk1 wdata_asic[41] wdata_ff[41] vdd vss /
+ DFCNQD1BWP7T30P140
Xwdata_reg1<6> ls_en_drv4[1] clk1 wdata_asic[40] wdata_ff[40] vdd vss /
+ DFCNQD1BWP7T30P140
Xwdata_reg1<5> ls_en_drv4[1] clk1 wdata_asic[39] wdata_ff[39] vdd vss /
+ DFCNQD1BWP7T30P140
Xwdata_reg1<4> ls_en_drv4[1] clk1 wdata_asic[38] wdata_ff[38] vdd vss /
+ DFCNQD1BWP7T30P140
Xwdata_reg1<3> ls_en_drv4[1] clk1 wdata_asic[37] wdata_ff[37] vdd vss /
+ DFCNQD1BWP7T30P140
Xwdata_reg1<2> ls_en_drv4[1] clk1 wdata_asic[36] wdata_ff[36] vdd vss /
+ DFCNQD1BWP7T30P140
Xwdata_reg1<1> ls_en_drv4[1] clk1 wdata_asic[35] wdata_ff[35] vdd vss /
+ DFCNQD1BWP7T30P140
Xwdata_reg1<0> ls_en_drv4[1] clk1 wdata_asic[34] wdata_ff[34] vdd vss /
+ DFCNQD1BWP7T30P140
Xwdata_reg14<16> ls_en_drv4[3] clk14 wdata_asic[237] wdata_ff[237] vdd vss /
+ DFCNQD1BWP7T30P140
Xwdata_reg14<15> ls_en_drv4[3] clk14 wdata_asic[236] wdata_ff[236] vdd vss /
+ DFCNQD1BWP7T30P140
Xwdata_reg14<14> ls_en_drv4[3] clk14 wdata_asic[235] wdata_ff[235] vdd vss /
+ DFCNQD1BWP7T30P140
Xwdata_reg14<13> ls_en_drv4[3] clk14 wdata_asic[234] wdata_ff[234] vdd vss /
+ DFCNQD1BWP7T30P140
Xwdata_reg14<12> ls_en_drv4[3] clk14 wdata_asic[233] wdata_ff[233] vdd vss /
+ DFCNQD1BWP7T30P140
Xwdata_reg14<11> ls_en_drv4[3] clk14 wdata_asic[232] wdata_ff[232] vdd vss /
+ DFCNQD1BWP7T30P140
Xwdata_reg14<10> ls_en_drv4[3] clk14 wdata_asic[231] wdata_ff[231] vdd vss /
+ DFCNQD1BWP7T30P140
Xwdata_reg14<9> ls_en_drv4[3] clk14 wdata_asic[230] wdata_ff[230] vdd vss /
+ DFCNQD1BWP7T30P140
Xwdata_reg14<8> ls_en_drv4[3] clk14 wdata_asic[229] wdata_ff[229] vdd vss /
+ DFCNQD1BWP7T30P140
Xwdata_reg14<7> ls_en_drv4[3] clk14 wdata_asic[228] wdata_ff[228] vdd vss /
+ DFCNQD1BWP7T30P140
Xwdata_reg14<6> ls_en_drv4[3] clk14 wdata_asic[227] wdata_ff[227] vdd vss /
+ DFCNQD1BWP7T30P140
Xwdata_reg14<5> ls_en_drv4[3] clk14 wdata_asic[226] wdata_ff[226] vdd vss /
+ DFCNQD1BWP7T30P140
Xwdata_reg14<4> ls_en_drv4[3] clk14 wdata_asic[225] wdata_ff[225] vdd vss /
+ DFCNQD1BWP7T30P140
Xwdata_reg14<3> ls_en_drv4[3] clk14 wdata_asic[224] wdata_ff[224] vdd vss /
+ DFCNQD1BWP7T30P140
Xwdata_reg14<2> ls_en_drv4[3] clk14 wdata_asic[223] wdata_ff[223] vdd vss /
+ DFCNQD1BWP7T30P140
Xwdata_reg14<1> ls_en_drv4[3] clk14 wdata_asic[222] wdata_ff[222] vdd vss /
+ DFCNQD1BWP7T30P140
Xwdata_reg14<0> ls_en_drv4[3] clk14 wdata_asic[221] wdata_ff[221] vdd vss /
+ DFCNQD1BWP7T30P140
Xwdata_reg4<16> ls_en_drv4[0] clk4 wdata_asic[152] wdata_ff[152] vdd vss /
+ DFCNQD1BWP7T30P140
Xwdata_reg4<15> ls_en_drv4[0] clk4 wdata_asic[151] wdata_ff[151] vdd vss /
+ DFCNQD1BWP7T30P140
Xwdata_reg4<14> ls_en_drv4[0] clk4 wdata_asic[150] wdata_ff[150] vdd vss /
+ DFCNQD1BWP7T30P140
Xwdata_reg4<13> ls_en_drv4[0] clk4 wdata_asic[149] wdata_ff[149] vdd vss /
+ DFCNQD1BWP7T30P140
Xwdata_reg4<12> ls_en_drv4[0] clk4 wdata_asic[148] wdata_ff[148] vdd vss /
+ DFCNQD1BWP7T30P140
Xwdata_reg4<11> ls_en_drv4[0] clk4 wdata_asic[147] wdata_ff[147] vdd vss /
+ DFCNQD1BWP7T30P140
Xwdata_reg4<10> ls_en_drv4[0] clk4 wdata_asic[146] wdata_ff[146] vdd vss /
+ DFCNQD1BWP7T30P140
Xwdata_reg4<9> ls_en_drv4[0] clk4 wdata_asic[145] wdata_ff[145] vdd vss /
+ DFCNQD1BWP7T30P140
Xwdata_reg4<8> ls_en_drv4[0] clk4 wdata_asic[144] wdata_ff[144] vdd vss /
+ DFCNQD1BWP7T30P140
Xwdata_reg4<7> ls_en_drv4[0] clk4 wdata_asic[143] wdata_ff[143] vdd vss /
+ DFCNQD1BWP7T30P140
Xwdata_reg4<6> ls_en_drv4[0] clk4 wdata_asic[142] wdata_ff[142] vdd vss /
+ DFCNQD1BWP7T30P140
Xwdata_reg4<5> ls_en_drv4[0] clk4 wdata_asic[141] wdata_ff[141] vdd vss /
+ DFCNQD1BWP7T30P140
Xwdata_reg4<4> ls_en_drv4[0] clk4 wdata_asic[140] wdata_ff[140] vdd vss /
+ DFCNQD1BWP7T30P140
Xwdata_reg4<3> ls_en_drv4[0] clk4 wdata_asic[139] wdata_ff[139] vdd vss /
+ DFCNQD1BWP7T30P140
Xwdata_reg4<2> ls_en_drv4[0] clk4 wdata_asic[138] wdata_ff[138] vdd vss /
+ DFCNQD1BWP7T30P140
Xwdata_reg4<1> ls_en_drv4[0] clk4 wdata_asic[137] wdata_ff[137] vdd vss /
+ DFCNQD1BWP7T30P140
Xwdata_reg4<0> ls_en_drv4[0] clk4 wdata_asic[136] wdata_ff[136] vdd vss /
+ DFCNQD1BWP7T30P140
Xgcadd_wr_reg<7> ls_en_drv3 clk_gcadd net27[7] gcadd_ff[7] vdd vss /
+ DFCNQD1BWP7T30P140
Xgcadd_wr_reg<6> ls_en_drv3 clk_gcadd net27[6] gcadd_ff[6] vdd vss /
+ DFCNQD1BWP7T30P140
Xgcadd_wr_reg<5> ls_en_drv3 clk_gcadd net27[5] gcadd_ff[5] vdd vss /
+ DFCNQD1BWP7T30P140
Xgcadd_wr_reg<4> ls_en_drv3 clk_gcadd net27[4] gcadd_ff[4] vdd vss /
+ DFCNQD1BWP7T30P140
Xgcadd_wr_reg<3> ls_en_drv3 clk_gcadd net27[3] gcadd_ff[3] vdd vss /
+ DFCNQD1BWP7T30P140
Xgcadd_wr_reg<2> ls_en_drv3 clk_gcadd net27[2] gcadd_ff[2] vdd vss /
+ DFCNQD1BWP7T30P140
Xgcadd_wr_reg<1> ls_en_drv3 clk_gcadd net27[1] gcadd_ff[1] vdd vss /
+ DFCNQD1BWP7T30P140
Xgcadd_wr_reg<0> ls_en_drv3 clk_gcadd net27[0] gcadd_ff[0] vdd vss /
+ DFCNQD1BWP7T30P140
Xwdata_reg9<16> ls_en_drv4[2] clk9 wdata_asic[67] wdata_ff[67] vdd vss /
+ DFCNQD1BWP7T30P140
Xwdata_reg9<15> ls_en_drv4[2] clk9 wdata_asic[66] wdata_ff[66] vdd vss /
+ DFCNQD1BWP7T30P140
Xwdata_reg9<14> ls_en_drv4[2] clk9 wdata_asic[65] wdata_ff[65] vdd vss /
+ DFCNQD1BWP7T30P140
Xwdata_reg9<13> ls_en_drv4[2] clk9 wdata_asic[64] wdata_ff[64] vdd vss /
+ DFCNQD1BWP7T30P140
Xwdata_reg9<12> ls_en_drv4[2] clk9 wdata_asic[63] wdata_ff[63] vdd vss /
+ DFCNQD1BWP7T30P140
Xwdata_reg9<11> ls_en_drv4[2] clk9 wdata_asic[62] wdata_ff[62] vdd vss /
+ DFCNQD1BWP7T30P140
Xwdata_reg9<10> ls_en_drv4[2] clk9 wdata_asic[61] wdata_ff[61] vdd vss /
+ DFCNQD1BWP7T30P140
Xwdata_reg9<9> ls_en_drv4[2] clk9 wdata_asic[60] wdata_ff[60] vdd vss /
+ DFCNQD1BWP7T30P140
Xwdata_reg9<8> ls_en_drv4[2] clk9 wdata_asic[59] wdata_ff[59] vdd vss /
+ DFCNQD1BWP7T30P140
Xwdata_reg9<7> ls_en_drv4[2] clk9 wdata_asic[58] wdata_ff[58] vdd vss /
+ DFCNQD1BWP7T30P140
Xwdata_reg9<6> ls_en_drv4[2] clk9 wdata_asic[57] wdata_ff[57] vdd vss /
+ DFCNQD1BWP7T30P140
Xwdata_reg9<5> ls_en_drv4[2] clk9 wdata_asic[56] wdata_ff[56] vdd vss /
+ DFCNQD1BWP7T30P140
Xwdata_reg9<4> ls_en_drv4[2] clk9 wdata_asic[55] wdata_ff[55] vdd vss /
+ DFCNQD1BWP7T30P140
Xwdata_reg9<3> ls_en_drv4[2] clk9 wdata_asic[54] wdata_ff[54] vdd vss /
+ DFCNQD1BWP7T30P140
Xwdata_reg9<2> ls_en_drv4[2] clk9 wdata_asic[53] wdata_ff[53] vdd vss /
+ DFCNQD1BWP7T30P140
Xwdata_reg9<1> ls_en_drv4[2] clk9 wdata_asic[52] wdata_ff[52] vdd vss /
+ DFCNQD1BWP7T30P140
Xwdata_reg9<0> ls_en_drv4[2] clk9 wdata_asic[51] wdata_ff[51] vdd vss /
+ DFCNQD1BWP7T30P140
Xwdata_reg11<16> ls_en_drv4[2] clk11 wdata_asic[135] wdata_ff[135] vdd vss /
+ DFCNQD1BWP7T30P140
Xwdata_reg11<15> ls_en_drv4[2] clk11 wdata_asic[134] wdata_ff[134] vdd vss /
+ DFCNQD1BWP7T30P140
Xwdata_reg11<14> ls_en_drv4[2] clk11 wdata_asic[133] wdata_ff[133] vdd vss /
+ DFCNQD1BWP7T30P140
Xwdata_reg11<13> ls_en_drv4[2] clk11 wdata_asic[132] wdata_ff[132] vdd vss /
+ DFCNQD1BWP7T30P140
Xwdata_reg11<12> ls_en_drv4[2] clk11 wdata_asic[131] wdata_ff[131] vdd vss /
+ DFCNQD1BWP7T30P140
Xwdata_reg11<11> ls_en_drv4[2] clk11 wdata_asic[130] wdata_ff[130] vdd vss /
+ DFCNQD1BWP7T30P140
Xwdata_reg11<10> ls_en_drv4[2] clk11 wdata_asic[129] wdata_ff[129] vdd vss /
+ DFCNQD1BWP7T30P140
Xwdata_reg11<9> ls_en_drv4[2] clk11 wdata_asic[128] wdata_ff[128] vdd vss /
+ DFCNQD1BWP7T30P140
Xwdata_reg11<8> ls_en_drv4[2] clk11 wdata_asic[127] wdata_ff[127] vdd vss /
+ DFCNQD1BWP7T30P140
Xwdata_reg11<7> ls_en_drv4[2] clk11 wdata_asic[126] wdata_ff[126] vdd vss /
+ DFCNQD1BWP7T30P140
Xwdata_reg11<6> ls_en_drv4[2] clk11 wdata_asic[125] wdata_ff[125] vdd vss /
+ DFCNQD1BWP7T30P140
Xwdata_reg11<5> ls_en_drv4[2] clk11 wdata_asic[124] wdata_ff[124] vdd vss /
+ DFCNQD1BWP7T30P140
Xwdata_reg11<4> ls_en_drv4[2] clk11 wdata_asic[123] wdata_ff[123] vdd vss /
+ DFCNQD1BWP7T30P140
Xwdata_reg11<3> ls_en_drv4[2] clk11 wdata_asic[122] wdata_ff[122] vdd vss /
+ DFCNQD1BWP7T30P140
Xwdata_reg11<2> ls_en_drv4[2] clk11 wdata_asic[121] wdata_ff[121] vdd vss /
+ DFCNQD1BWP7T30P140
Xwdata_reg11<1> ls_en_drv4[2] clk11 wdata_asic[120] wdata_ff[120] vdd vss /
+ DFCNQD1BWP7T30P140
Xwdata_reg11<0> ls_en_drv4[2] clk11 wdata_asic[119] wdata_ff[119] vdd vss /
+ DFCNQD1BWP7T30P140
Xwdata_reg13<16> ls_en_drv4[3] clk13 wdata_asic[203] wdata_ff[203] vdd vss /
+ DFCNQD1BWP7T30P140
Xwdata_reg13<15> ls_en_drv4[3] clk13 wdata_asic[202] wdata_ff[202] vdd vss /
+ DFCNQD1BWP7T30P140
Xwdata_reg13<14> ls_en_drv4[3] clk13 wdata_asic[201] wdata_ff[201] vdd vss /
+ DFCNQD1BWP7T30P140
Xwdata_reg13<13> ls_en_drv4[3] clk13 wdata_asic[200] wdata_ff[200] vdd vss /
+ DFCNQD1BWP7T30P140
Xwdata_reg13<12> ls_en_drv4[3] clk13 wdata_asic[199] wdata_ff[199] vdd vss /
+ DFCNQD1BWP7T30P140
Xwdata_reg13<11> ls_en_drv4[3] clk13 wdata_asic[198] wdata_ff[198] vdd vss /
+ DFCNQD1BWP7T30P140
Xwdata_reg13<10> ls_en_drv4[3] clk13 wdata_asic[197] wdata_ff[197] vdd vss /
+ DFCNQD1BWP7T30P140
Xwdata_reg13<9> ls_en_drv4[3] clk13 wdata_asic[196] wdata_ff[196] vdd vss /
+ DFCNQD1BWP7T30P140
Xwdata_reg13<8> ls_en_drv4[3] clk13 wdata_asic[195] wdata_ff[195] vdd vss /
+ DFCNQD1BWP7T30P140
Xwdata_reg13<7> ls_en_drv4[3] clk13 wdata_asic[194] wdata_ff[194] vdd vss /
+ DFCNQD1BWP7T30P140
Xwdata_reg13<6> ls_en_drv4[3] clk13 wdata_asic[193] wdata_ff[193] vdd vss /
+ DFCNQD1BWP7T30P140
Xwdata_reg13<5> ls_en_drv4[3] clk13 wdata_asic[192] wdata_ff[192] vdd vss /
+ DFCNQD1BWP7T30P140
Xwdata_reg13<4> ls_en_drv4[3] clk13 wdata_asic[191] wdata_ff[191] vdd vss /
+ DFCNQD1BWP7T30P140
Xwdata_reg13<3> ls_en_drv4[3] clk13 wdata_asic[190] wdata_ff[190] vdd vss /
+ DFCNQD1BWP7T30P140
Xwdata_reg13<2> ls_en_drv4[3] clk13 wdata_asic[189] wdata_ff[189] vdd vss /
+ DFCNQD1BWP7T30P140
Xwdata_reg13<1> ls_en_drv4[3] clk13 wdata_asic[188] wdata_ff[188] vdd vss /
+ DFCNQD1BWP7T30P140
Xwdata_reg13<0> ls_en_drv4[3] clk13 wdata_asic[187] wdata_ff[187] vdd vss /
+ DFCNQD1BWP7T30P140
Xwdata_reg5<16> ls_en_drv4[0] clk5 wdata_asic[186] wdata_ff[186] vdd vss /
+ DFCNQD1BWP7T30P140
Xwdata_reg5<15> ls_en_drv4[0] clk5 wdata_asic[185] wdata_ff[185] vdd vss /
+ DFCNQD1BWP7T30P140
Xwdata_reg5<14> ls_en_drv4[0] clk5 wdata_asic[184] wdata_ff[184] vdd vss /
+ DFCNQD1BWP7T30P140
Xwdata_reg5<13> ls_en_drv4[0] clk5 wdata_asic[183] wdata_ff[183] vdd vss /
+ DFCNQD1BWP7T30P140
Xwdata_reg5<12> ls_en_drv4[0] clk5 wdata_asic[182] wdata_ff[182] vdd vss /
+ DFCNQD1BWP7T30P140
Xwdata_reg5<11> ls_en_drv4[0] clk5 wdata_asic[181] wdata_ff[181] vdd vss /
+ DFCNQD1BWP7T30P140
Xwdata_reg5<10> ls_en_drv4[0] clk5 wdata_asic[180] wdata_ff[180] vdd vss /
+ DFCNQD1BWP7T30P140
Xwdata_reg5<9> ls_en_drv4[0] clk5 wdata_asic[179] wdata_ff[179] vdd vss /
+ DFCNQD1BWP7T30P140
Xwdata_reg5<8> ls_en_drv4[0] clk5 wdata_asic[178] wdata_ff[178] vdd vss /
+ DFCNQD1BWP7T30P140
Xwdata_reg5<7> ls_en_drv4[0] clk5 wdata_asic[177] wdata_ff[177] vdd vss /
+ DFCNQD1BWP7T30P140
Xwdata_reg5<6> ls_en_drv4[0] clk5 wdata_asic[176] wdata_ff[176] vdd vss /
+ DFCNQD1BWP7T30P140
Xwdata_reg5<5> ls_en_drv4[0] clk5 wdata_asic[175] wdata_ff[175] vdd vss /
+ DFCNQD1BWP7T30P140
Xwdata_reg5<4> ls_en_drv4[0] clk5 wdata_asic[174] wdata_ff[174] vdd vss /
+ DFCNQD1BWP7T30P140
Xwdata_reg5<3> ls_en_drv4[0] clk5 wdata_asic[173] wdata_ff[173] vdd vss /
+ DFCNQD1BWP7T30P140
Xwdata_reg5<2> ls_en_drv4[0] clk5 wdata_asic[172] wdata_ff[172] vdd vss /
+ DFCNQD1BWP7T30P140
Xwdata_reg5<1> ls_en_drv4[0] clk5 wdata_asic[171] wdata_ff[171] vdd vss /
+ DFCNQD1BWP7T30P140
Xwdata_reg5<0> ls_en_drv4[0] clk5 wdata_asic[170] wdata_ff[170] vdd vss /
+ DFCNQD1BWP7T30P140
Xgradd_n_reg<12> ls_en_drv3 clk_gradd net28[12] gradd_ff[12] vdd vss /
+ DFCNQD1BWP7T30P140
Xgradd_n_reg<11> ls_en_drv3 clk_gradd net28[11] gradd_ff[11] vdd vss /
+ DFCNQD1BWP7T30P140
Xgradd_n_reg<10> ls_en_drv3 clk_gradd net28[10] gradd_ff[10] vdd vss /
+ DFCNQD1BWP7T30P140
Xgradd_n_reg<9> ls_en_drv3 clk_gradd net28[9] gradd_ff[9] vdd vss /
+ DFCNQD1BWP7T30P140
Xgradd_n_reg<8> ls_en_drv3 clk_gradd net28[8] gradd_ff[8] vdd vss /
+ DFCNQD1BWP7T30P140
Xgradd_n_reg<7> ls_en_drv3 clk_gradd net28[7] gradd_ff[7] vdd vss /
+ DFCNQD1BWP7T30P140
Xgradd_n_reg<6> ls_en_drv3 clk_gradd net28[6] gradd_ff[6] vdd vss /
+ DFCNQD1BWP7T30P140
Xgradd_n_reg<5> ls_en_drv3 clk_gradd net28[5] gradd_ff[5] vdd vss /
+ DFCNQD1BWP7T30P140
Xgradd_n_reg<4> ls_en_drv3 clk_gradd net28[4] gradd_ff[4] vdd vss /
+ DFCNQD1BWP7T30P140
Xgradd_n_reg<3> ls_en_drv3 clk_gradd net28[3] gradd_ff[3] vdd vss /
+ DFCNQD1BWP7T30P140
Xgradd_n_reg<2> ls_en_drv3 clk_gradd net28[2] gradd_ff[2] vdd vss /
+ DFCNQD1BWP7T30P140
Xgradd_n_reg<1> ls_en_drv3 clk_gradd net28[1] gradd_ff[1] vdd vss /
+ DFCNQD1BWP7T30P140
Xgradd_n_reg<0> ls_en_drv3 clk_gradd net28[0] gradd_ff[0] vdd vss /
+ DFCNQD1BWP7T30P140
Xwdata_reg0<16> ls_en_drv4[1] clk0 wdata_asic[16] wdata_ff[16] vdd vss /
+ DFCNQD1BWP7T30P140
Xwdata_reg0<15> ls_en_drv4[1] clk0 wdata_asic[15] wdata_ff[15] vdd vss /
+ DFCNQD1BWP7T30P140
Xwdata_reg0<14> ls_en_drv4[1] clk0 wdata_asic[14] wdata_ff[14] vdd vss /
+ DFCNQD1BWP7T30P140
Xwdata_reg0<13> ls_en_drv4[1] clk0 wdata_asic[13] wdata_ff[13] vdd vss /
+ DFCNQD1BWP7T30P140
Xwdata_reg0<12> ls_en_drv4[1] clk0 wdata_asic[12] wdata_ff[12] vdd vss /
+ DFCNQD1BWP7T30P140
Xwdata_reg0<11> ls_en_drv4[1] clk0 wdata_asic[11] wdata_ff[11] vdd vss /
+ DFCNQD1BWP7T30P140
Xwdata_reg0<10> ls_en_drv4[1] clk0 wdata_asic[10] wdata_ff[10] vdd vss /
+ DFCNQD1BWP7T30P140
Xwdata_reg0<9> ls_en_drv4[1] clk0 wdata_asic[9] wdata_ff[9] vdd vss /
+ DFCNQD1BWP7T30P140
Xwdata_reg0<8> ls_en_drv4[1] clk0 wdata_asic[8] wdata_ff[8] vdd vss /
+ DFCNQD1BWP7T30P140
Xwdata_reg0<7> ls_en_drv4[1] clk0 wdata_asic[7] wdata_ff[7] vdd vss /
+ DFCNQD1BWP7T30P140
Xwdata_reg0<6> ls_en_drv4[1] clk0 wdata_asic[6] wdata_ff[6] vdd vss /
+ DFCNQD1BWP7T30P140
Xwdata_reg0<5> ls_en_drv4[1] clk0 wdata_asic[5] wdata_ff[5] vdd vss /
+ DFCNQD1BWP7T30P140
Xwdata_reg0<4> ls_en_drv4[1] clk0 wdata_asic[4] wdata_ff[4] vdd vss /
+ DFCNQD1BWP7T30P140
Xwdata_reg0<3> ls_en_drv4[1] clk0 wdata_asic[3] wdata_ff[3] vdd vss /
+ DFCNQD1BWP7T30P140
Xwdata_reg0<2> ls_en_drv4[1] clk0 wdata_asic[2] wdata_ff[2] vdd vss /
+ DFCNQD1BWP7T30P140
Xwdata_reg0<1> ls_en_drv4[1] clk0 wdata_asic[1] wdata_ff[1] vdd vss /
+ DFCNQD1BWP7T30P140
Xwdata_reg0<0> ls_en_drv4[1] clk0 wdata_asic[0] wdata_ff[0] vdd vss /
+ DFCNQD1BWP7T30P140
Xwdata_reg2<16> ls_en_drv4[1] clk2 wdata_asic[84] wdata_ff[84] vdd vss /
+ DFCNQD1BWP7T30P140
Xwdata_reg2<15> ls_en_drv4[1] clk2 wdata_asic[83] wdata_ff[83] vdd vss /
+ DFCNQD1BWP7T30P140
Xwdata_reg2<14> ls_en_drv4[1] clk2 wdata_asic[82] wdata_ff[82] vdd vss /
+ DFCNQD1BWP7T30P140
Xwdata_reg2<13> ls_en_drv4[1] clk2 wdata_asic[81] wdata_ff[81] vdd vss /
+ DFCNQD1BWP7T30P140
Xwdata_reg2<12> ls_en_drv4[1] clk2 wdata_asic[80] wdata_ff[80] vdd vss /
+ DFCNQD1BWP7T30P140
Xwdata_reg2<11> ls_en_drv4[1] clk2 wdata_asic[79] wdata_ff[79] vdd vss /
+ DFCNQD1BWP7T30P140
Xwdata_reg2<10> ls_en_drv4[1] clk2 wdata_asic[78] wdata_ff[78] vdd vss /
+ DFCNQD1BWP7T30P140
Xwdata_reg2<9> ls_en_drv4[1] clk2 wdata_asic[77] wdata_ff[77] vdd vss /
+ DFCNQD1BWP7T30P140
Xwdata_reg2<8> ls_en_drv4[1] clk2 wdata_asic[76] wdata_ff[76] vdd vss /
+ DFCNQD1BWP7T30P140
Xwdata_reg2<7> ls_en_drv4[1] clk2 wdata_asic[75] wdata_ff[75] vdd vss /
+ DFCNQD1BWP7T30P140
Xwdata_reg2<6> ls_en_drv4[1] clk2 wdata_asic[74] wdata_ff[74] vdd vss /
+ DFCNQD1BWP7T30P140
Xwdata_reg2<5> ls_en_drv4[1] clk2 wdata_asic[73] wdata_ff[73] vdd vss /
+ DFCNQD1BWP7T30P140
Xwdata_reg2<4> ls_en_drv4[1] clk2 wdata_asic[72] wdata_ff[72] vdd vss /
+ DFCNQD1BWP7T30P140
Xwdata_reg2<3> ls_en_drv4[1] clk2 wdata_asic[71] wdata_ff[71] vdd vss /
+ DFCNQD1BWP7T30P140
Xwdata_reg2<2> ls_en_drv4[1] clk2 wdata_asic[70] wdata_ff[70] vdd vss /
+ DFCNQD1BWP7T30P140
Xwdata_reg2<1> ls_en_drv4[1] clk2 wdata_asic[69] wdata_ff[69] vdd vss /
+ DFCNQD1BWP7T30P140
Xwdata_reg2<0> ls_en_drv4[1] clk2 wdata_asic[68] wdata_ff[68] vdd vss /
+ DFCNQD1BWP7T30P140
Xwdata_reg12<16> ls_en_drv4[3] clk12 wdata_asic[169] wdata_ff[169] vdd vss /
+ DFCNQD1BWP7T30P140
Xwdata_reg12<15> ls_en_drv4[3] clk12 wdata_asic[168] wdata_ff[168] vdd vss /
+ DFCNQD1BWP7T30P140
Xwdata_reg12<14> ls_en_drv4[3] clk12 wdata_asic[167] wdata_ff[167] vdd vss /
+ DFCNQD1BWP7T30P140
Xwdata_reg12<13> ls_en_drv4[3] clk12 wdata_asic[166] wdata_ff[166] vdd vss /
+ DFCNQD1BWP7T30P140
Xwdata_reg12<12> ls_en_drv4[3] clk12 wdata_asic[165] wdata_ff[165] vdd vss /
+ DFCNQD1BWP7T30P140
Xwdata_reg12<11> ls_en_drv4[3] clk12 wdata_asic[164] wdata_ff[164] vdd vss /
+ DFCNQD1BWP7T30P140
Xwdata_reg12<10> ls_en_drv4[3] clk12 wdata_asic[163] wdata_ff[163] vdd vss /
+ DFCNQD1BWP7T30P140
Xwdata_reg12<9> ls_en_drv4[3] clk12 wdata_asic[162] wdata_ff[162] vdd vss /
+ DFCNQD1BWP7T30P140
Xwdata_reg12<8> ls_en_drv4[3] clk12 wdata_asic[161] wdata_ff[161] vdd vss /
+ DFCNQD1BWP7T30P140
Xwdata_reg12<7> ls_en_drv4[3] clk12 wdata_asic[160] wdata_ff[160] vdd vss /
+ DFCNQD1BWP7T30P140
Xwdata_reg12<6> ls_en_drv4[3] clk12 wdata_asic[159] wdata_ff[159] vdd vss /
+ DFCNQD1BWP7T30P140
Xwdata_reg12<5> ls_en_drv4[3] clk12 wdata_asic[158] wdata_ff[158] vdd vss /
+ DFCNQD1BWP7T30P140
Xwdata_reg12<4> ls_en_drv4[3] clk12 wdata_asic[157] wdata_ff[157] vdd vss /
+ DFCNQD1BWP7T30P140
Xwdata_reg12<3> ls_en_drv4[3] clk12 wdata_asic[156] wdata_ff[156] vdd vss /
+ DFCNQD1BWP7T30P140
Xwdata_reg12<2> ls_en_drv4[3] clk12 wdata_asic[155] wdata_ff[155] vdd vss /
+ DFCNQD1BWP7T30P140
Xwdata_reg12<1> ls_en_drv4[3] clk12 wdata_asic[154] wdata_ff[154] vdd vss /
+ DFCNQD1BWP7T30P140
Xwdata_reg12<0> ls_en_drv4[3] clk12 wdata_asic[153] wdata_ff[153] vdd vss /
+ DFCNQD1BWP7T30P140
Xasic_out_en_reg ls_en_drv4[0] clk_asic_out_en net64 asic_out_en_ff vdd vss /
+ DFCNQD1BWP7T30P140
Xi324 net3 cc_bnksel_n_d0_dly_1 net11 net10 net9 net12 net7 net6 net5 net4 vdd
+ vss / hb_macro_dly_full
Xi75 net0127 cc_bnksel_n_d0_dly_0 net464 net469 net471 net468 net467 net466
+ net470 net465 vdd vss / hb_macro_dly_full
CC0 out_en[0] vss 500f $[CP]
CC1 out_en[1] vss 500f $[CP]
.ENDS
