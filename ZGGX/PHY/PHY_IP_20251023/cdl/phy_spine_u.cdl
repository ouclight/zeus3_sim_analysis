************************************************************************
* auCdl Netlist:
*
* Library Name:  BJ_IF_TSMCN28_PHY_SCH_V100
* Top Cell Name: phy_spine_u
* View Name:     schematic
* Netlisted on:  Oct 21 13:58:09 2025
************************************************************************

*.BIPOLAR
*.RESI = 2000
*.RESVAL
*.CAPVAL
*.DIOPERI
*.DIOAREA
*.EQUATION
*.SCALE METER
*.MEGA
.PARAM

************************************************************************
* Library Name: BJ_IF_TSMCN28_PHY_SCH_V100
* Cell Name:    physpineu_hb_diode
* View Name:    schematic
************************************************************************

.SUBCKT physpineu_hb_diode inp vdd vss
*.PININFO inp:I vdd:B vss:B
MNM0 inp vss vss vss nch_18ud12_mac l=90n w=400n m=1 nf=1
MPM0 inp vdd vdd vdd pch_18ud12_mac l=90n w=400n m=1 nf=1
.ENDS

************************************************************************
* Library Name: BJ_IF_TSMCN28_PHY_SCH_V100
* Cell Name:    physpineu_INVD2BWP7T30P140
* View Name:    schematic
************************************************************************

.SUBCKT physpineu_INVD2BWP7T30P140 I VDD VSS ZN
*.PININFO I:B VDD:B VSS:B ZN:B
MMM1 ZN I VSS VSS nch_mac l=30n w=200n m=1 nf=1
MMM1_2 ZN I VSS VSS nch_mac l=30n w=200n m=1 nf=1
MMM0 ZN I VDD VDD pch_mac l=30n w=220.0n m=1 nf=1
MMM0_2 ZN I VDD VDD pch_mac l=30n w=220.0n m=1 nf=1
.ENDS

************************************************************************
* Library Name: BJ_IF_TSMCN28_PHY_SCH_V100
* Cell Name:    physpineu_Levelshift_1p1
* View Name:    schematic
************************************************************************

.SUBCKT physpineu_Levelshift_1p1 D DVDD DVSS D_ls VDD VSS
*.PININFO D:I D_ls:O DVDD:B DVSS:B VDD:B VSS:B
Xi3 D VDD VSS D_n / physpineu_INVD2BWP7T30P140
MN1 net5 D DVSS DVSS nch_18ud12_mac l=90n w=1.6u m=2 nf=1
MN2 D_ls D_n DVSS DVSS nch_18ud12_mac l=90n w=1.6u m=2 nf=1
MP2 net13 net5 DVDD DVDD pch_18ud12_mac l=90n w=1.6u m=2 nf=1
MP3 net5 D net14 DVDD pch_18ud12_mac l=90n w=1.6u m=2 nf=1
MP1 net14 D_ls DVDD DVDD pch_18ud12_mac l=90n w=1.6u m=2 nf=1
MP4 D_ls D_n net13 DVDD pch_18ud12_mac l=90n w=1.6u m=2 nf=1
.ENDS

************************************************************************
* Library Name: BJ_IF_TSMCN28_PHY_SCH_V100
* Cell Name:    physpineu_Levelshift_1p1buf
* View Name:    schematic
************************************************************************

.SUBCKT physpineu_Levelshift_1p1buf DVDD DVSS Din Dout VDD VSS
*.PININFO Din:I Dout:O DVDD:B DVSS:B VDD:B VSS:B
MM4 DVDD DVDD DVDD DVDD pch_18ud12_mac l=90n w=1.6u m=6 nf=1
MM2 Dout D_ls_b DVDD DVDD pch_18ud12_mac l=90n w=1.6u m=10 nf=1
MM1 D_ls_b D_ls DVDD DVDD pch_18ud12_mac l=90n w=1.6u m=2 nf=1
XI3 Din DVDD DVSS D_ls VDD VSS / physpineu_Levelshift_1p1
MM5 DVSS DVSS DVSS DVSS nch_18ud12_mac l=90n w=1.6u m=2 nf=1
MM0 D_ls_b D_ls DVSS DVSS nch_18ud12_mac l=90n w=1.6u m=1 nf=1
MM3 Dout D_ls_b DVSS DVSS nch_18ud12_mac l=90n w=1.6u m=5 nf=1
.ENDS

************************************************************************
* Library Name: BJ_IF_TSMCN28_PHY_SCH_V100
* Cell Name:    physpineu_ND2D2BWP7T30P140
* View Name:    schematic
************************************************************************

.SUBCKT physpineu_ND2D2BWP7T30P140 A1 A2 VDD VSS ZN
*.PININFO A1:B A2:B VDD:B VSS:B ZN:B
MMM4 ZN A1 net10 VSS nch_mac l=30n w=200n m=1 nf=1
MMM4_2 ZN A1 net10 VSS nch_mac l=30n w=200n m=1 nf=1
MMM9 net10 A2 VSS VSS nch_mac l=30n w=200n m=1 nf=1
MMM9_2 net10 A2 VSS VSS nch_mac l=30n w=200n m=1 nf=1
MMM1 ZN A1 VDD VDD pch_mac l=30n w=210.0n m=1 nf=1
MMM1_2 ZN A1 VDD VDD pch_mac l=30n w=210.0n m=1 nf=1
MMM2 ZN A2 VDD VDD pch_mac l=30n w=210.0n m=1 nf=1
MMM2_2 ZN A2 VDD VDD pch_mac l=30n w=210.0n m=1 nf=1
.ENDS

************************************************************************
* Library Name: BJ_IF_TSMCN28_PHY_SCH_V100
* Cell Name:    physpineu_TIEHBWP7T30P140
* View Name:    schematic
************************************************************************

.SUBCKT physpineu_TIEHBWP7T30P140 VDD VSS Z
*.PININFO VDD:B VSS:B Z:B
MMM8 net10 net10 VSS VSS nch_mac l=30n w=200n m=1 nf=1
MMM5 Z net10 VDD VDD pch_mac l=30n w=220.0n m=1 nf=1
.ENDS

************************************************************************
* Library Name: BJ_IF_TSMCN28_PHY_SCH_V100
* Cell Name:    physpineu_BUFFD16BWP7T30P140
* View Name:    schematic
************************************************************************

.SUBCKT physpineu_BUFFD16BWP7T30P140 I VDD VSS Z
*.PININFO I:B VDD:B VSS:B Z:B
MMM0 Z net9 VSS VSS nch_mac l=30n w=200n m=1 nf=1
MMM0_2 Z net9 VSS VSS nch_mac l=30n w=200n m=1 nf=1
MMM0_3 Z net9 VSS VSS nch_mac l=30n w=200n m=1 nf=1
MMM0_4 Z net9 VSS VSS nch_mac l=30n w=200n m=1 nf=1
MMM0_5 Z net9 VSS VSS nch_mac l=30n w=200n m=1 nf=1
MMM0_6 Z net9 VSS VSS nch_mac l=30n w=200n m=1 nf=1
MMM0_7 Z net9 VSS VSS nch_mac l=30n w=200n m=1 nf=1
MMM0_8 Z net9 VSS VSS nch_mac l=30n w=200n m=1 nf=1
MMM0_9 Z net9 VSS VSS nch_mac l=30n w=200n m=1 nf=1
MMM0_10 Z net9 VSS VSS nch_mac l=30n w=200n m=1 nf=1
MMM0_11 Z net9 VSS VSS nch_mac l=30n w=200n m=1 nf=1
MMM0_12 Z net9 VSS VSS nch_mac l=30n w=200n m=1 nf=1
MMM0_13 Z net9 VSS VSS nch_mac l=30n w=200n m=1 nf=1
MMM0_14 Z net9 VSS VSS nch_mac l=30n w=200n m=1 nf=1
MMM0_15 Z net9 VSS VSS nch_mac l=30n w=200n m=1 nf=1
MMM0_16 Z net9 VSS VSS nch_mac l=30n w=200n m=1 nf=1
MMM5 net9 I VSS VSS nch_mac l=30n w=200n m=1 nf=1
MMM5_2 net9 I VSS VSS nch_mac l=30n w=200n m=1 nf=1
MMM5_3 net9 I VSS VSS nch_mac l=30n w=200n m=1 nf=1
MMM5_4 net9 I VSS VSS nch_mac l=30n w=200n m=1 nf=1
MMM5_5 net9 I VSS VSS nch_mac l=30n w=200n m=1 nf=1
MMM1 Z net9 VDD VDD pch_mac l=30n w=220.0n m=1 nf=1
MMM1_2 Z net9 VDD VDD pch_mac l=30n w=220.0n m=1 nf=1
MMM1_3 Z net9 VDD VDD pch_mac l=30n w=220.0n m=1 nf=1
MMM1_4 Z net9 VDD VDD pch_mac l=30n w=220.0n m=1 nf=1
MMM1_5 Z net9 VDD VDD pch_mac l=30n w=220.0n m=1 nf=1
MMM1_6 Z net9 VDD VDD pch_mac l=30n w=220.0n m=1 nf=1
MMM1_7 Z net9 VDD VDD pch_mac l=30n w=220.0n m=1 nf=1
MMM1_8 Z net9 VDD VDD pch_mac l=30n w=220.0n m=1 nf=1
MMM1_9 Z net9 VDD VDD pch_mac l=30n w=220.0n m=1 nf=1
MMM1_10 Z net9 VDD VDD pch_mac l=30n w=220.0n m=1 nf=1
MMM1_11 Z net9 VDD VDD pch_mac l=30n w=220.0n m=1 nf=1
MMM1_12 Z net9 VDD VDD pch_mac l=30n w=220.0n m=1 nf=1
MMM1_13 Z net9 VDD VDD pch_mac l=30n w=220.0n m=1 nf=1
MMM1_14 Z net9 VDD VDD pch_mac l=30n w=220.0n m=1 nf=1
MMM1_15 Z net9 VDD VDD pch_mac l=30n w=220.0n m=1 nf=1
MMM1_16 Z net9 VDD VDD pch_mac l=30n w=220.0n m=1 nf=1
MMM4 net9 I VDD VDD pch_mac l=30n w=220.0n m=1 nf=1
MMM4_2 net9 I VDD VDD pch_mac l=30n w=220.0n m=1 nf=1
MMM4_3 net9 I VDD VDD pch_mac l=30n w=220.0n m=1 nf=1
MMM4_4 net9 I VDD VDD pch_mac l=30n w=220.0n m=1 nf=1
MMM4_5 net9 I VDD VDD pch_mac l=30n w=220.0n m=1 nf=1
.ENDS

************************************************************************
* Library Name: BJ_IF_TSMCN28_PHY_SCH_V100
* Cell Name:    physpineu_BUFFD4BWP7T30P140
* View Name:    schematic
************************************************************************

.SUBCKT physpineu_BUFFD4BWP7T30P140 I VDD VSS Z
*.PININFO I:B VDD:B VSS:B Z:B
MMM0 Z net9 VSS VSS nch_mac l=30n w=200n m=1 nf=1
MMM0_2 Z net9 VSS VSS nch_mac l=30n w=200n m=1 nf=1
MMM0_3 Z net9 VSS VSS nch_mac l=30n w=200n m=1 nf=1
MMM0_4 Z net9 VSS VSS nch_mac l=30n w=200n m=1 nf=1
MMM5 net9 I VSS VSS nch_mac l=30n w=200n m=1 nf=1
MMM5_2 net9 I VSS VSS nch_mac l=30n w=200n m=1 nf=1
MMM1 Z net9 VDD VDD pch_mac l=30n w=220.0n m=1 nf=1
MMM1_2 Z net9 VDD VDD pch_mac l=30n w=220.0n m=1 nf=1
MMM1_3 Z net9 VDD VDD pch_mac l=30n w=220.0n m=1 nf=1
MMM1_4 Z net9 VDD VDD pch_mac l=30n w=220.0n m=1 nf=1
MMM4 net9 I VDD VDD pch_mac l=30n w=220.0n m=1 nf=1
MMM4_2 net9 I VDD VDD pch_mac l=30n w=220.0n m=1 nf=1
.ENDS

************************************************************************
* Library Name: BJ_IF_TSMCN28_PHY_SCH_V100
* Cell Name:    physpineu_phy_latch_nand2_hv_x1
* View Name:    schematic
************************************************************************

.SUBCKT physpineu_phy_latch_nand2_hv_x1 A1 A2 VDD VSS ZN
*.PININFO A1:I A2:I ZN:O VDD:B VSS:B
MNM1 net17 A2 VSS VSS nch_18ud12_mac l=90n w=400n m=2 nf=1
MNM0 ZN A1 net17 VSS nch_18ud12_mac l=90n w=400n m=2 nf=1
MPM1 ZN A2 VDD VDD pch_18ud12_mac l=90n w=400n m=2 nf=1
MPM0 ZN A1 VDD VDD pch_18ud12_mac l=90n w=400n m=2 nf=1
.ENDS

************************************************************************
* Library Name: BJ_IF_TSMCN28_PHY_SCH_V100
* Cell Name:    physpineu_phy_latch_inv_hv_x1p5
* View Name:    schematic
************************************************************************

.SUBCKT physpineu_phy_latch_inv_hv_x1p5 A VDD_ARRAY VSS_ARRAY Y
*.PININFO A:I Y:O VDD_ARRAY:B VSS_ARRAY:B
MPM0 Y A VDD_ARRAY VDD_ARRAY pch_18ud12_mac l=90n w=400n m=2 nf=1
MNM0 Y A VSS_ARRAY VSS_ARRAY nch_18ud12_mac l=90n w=400n m=2 nf=1
.ENDS

************************************************************************
* Library Name: BJ_IF_TSMCN28_PHY_SCH_V100
* Cell Name:    physpineu_level_shift_latch
* View Name:    schematic
************************************************************************

.SUBCKT physpineu_level_shift_latch D DVDD DVSS VDD VSS en out pd_b pu_b
*.PININFO D:I en:I pd_b:I pu_b:I out:O DVDD:B DVSS:B VDD:B VSS:B
Xi6 D_ls en VDD VSS net033 / physpineu_ND2D2BWP7T30P140
Xi9 net019 VDD VSS out / physpineu_BUFFD4BWP7T30P140
MPM1 D_n D VDD VDD pch_18ud12_mac l=90n w=1.6u m=1 nf=1
Xi8 net033 VDD VSS net019 / physpineu_INVD2BWP7T30P140
Xi5 D_n VDD VSS D_ls / physpineu_INVD2BWP7T30P140
MNM3 D_n D VSS VSS nch_18ud12_mac l=90n w=1.6u m=1 nf=1
.ENDS

************************************************************************
* Library Name: BJ_IF_TSMCN28_PHY_SCH_V100
* Cell Name:    physpineu_asic_in_latch
* View Name:    schematic
************************************************************************

.SUBCKT physpineu_asic_in_latch A LS_en Y pd_n pu_n vdd vdd_array vss vss_array
*.PININFO A:I LS_en:I pd_n:I pu_n:I vdd:I vdd_array:I vss:I vss_array:I Y:O
Xi6 A LS_en vdd_array vss_array net09 / physpineu_phy_latch_nand2_hv_x1
Xi5 net09 vdd_array vss_array A / physpineu_phy_latch_inv_hv_x1p5
Xi1<1> net7 vdd vss Y / physpineu_BUFFD16BWP7T30P140
Xi1<0> net7 vdd vss Y / physpineu_BUFFD16BWP7T30P140
Xlevel_shift A vdd_array vss_array vdd vss LS_en net7 pd_n pu_n /
+ physpineu_level_shift_latch
.ENDS

************************************************************************
* Library Name: BJ_IF_TSMCN28_PHY_SCH_V100
* Cell Name:    physpineu_BUFFD12BWP7T30P140
* View Name:    schematic
************************************************************************

.SUBCKT physpineu_BUFFD12BWP7T30P140 I VDD VSS Z
*.PININFO I:B VDD:B VSS:B Z:B
MMM0 Z net55 VSS VSS nch_mac l=30n w=200n m=1 nf=1
MMM0_2 Z net55 VSS VSS nch_mac l=30n w=200n m=1 nf=1
MMM0_3 Z net55 VSS VSS nch_mac l=30n w=200n m=1 nf=1
MMM0_4 Z net55 VSS VSS nch_mac l=30n w=200n m=1 nf=1
MMM0_5 Z net55 VSS VSS nch_mac l=30n w=200n m=1 nf=1
MMM0_6 Z net55 VSS VSS nch_mac l=30n w=200n m=1 nf=1
MMM0_7 Z net55 VSS VSS nch_mac l=30n w=200n m=1 nf=1
MMM0_8 Z net55 VSS VSS nch_mac l=30n w=200n m=1 nf=1
MMM0_9 Z net55 VSS VSS nch_mac l=30n w=200n m=1 nf=1
MMM0_10 Z net55 VSS VSS nch_mac l=30n w=200n m=1 nf=1
MMM0_11 Z net55 VSS VSS nch_mac l=30n w=200n m=1 nf=1
MMM0_12 Z net55 VSS VSS nch_mac l=30n w=200n m=1 nf=1
MMM19 net55 I VSS VSS nch_mac l=30n w=200n m=1 nf=1
MMM19_2 net55 I VSS VSS nch_mac l=30n w=200n m=1 nf=1
MMM19_3 net55 I VSS VSS nch_mac l=30n w=200n m=1 nf=1
MMM19_4 net55 I VSS VSS nch_mac l=30n w=200n m=1 nf=1
MMM21 net55 I VDD VDD pch_mac l=30n w=220.0n m=1 nf=1
MMM21_2 net55 I VDD VDD pch_mac l=30n w=220.0n m=1 nf=1
MMM21_3 net55 I VDD VDD pch_mac l=30n w=220.0n m=1 nf=1
MMM21_4 net55 I VDD VDD pch_mac l=30n w=220.0n m=1 nf=1
MMM20 Z net55 VDD VDD pch_mac l=30n w=220.0n m=1 nf=1
MMM20_2 Z net55 VDD VDD pch_mac l=30n w=220.0n m=1 nf=1
MMM20_3 Z net55 VDD VDD pch_mac l=30n w=220.0n m=1 nf=1
MMM20_4 Z net55 VDD VDD pch_mac l=30n w=220.0n m=1 nf=1
MMM20_5 Z net55 VDD VDD pch_mac l=30n w=220.0n m=1 nf=1
MMM20_6 Z net55 VDD VDD pch_mac l=30n w=220.0n m=1 nf=1
MMM20_7 Z net55 VDD VDD pch_mac l=30n w=220.0n m=1 nf=1
MMM20_8 Z net55 VDD VDD pch_mac l=30n w=220.0n m=1 nf=1
MMM20_9 Z net55 VDD VDD pch_mac l=30n w=220.0n m=1 nf=1
MMM20_10 Z net55 VDD VDD pch_mac l=30n w=220.0n m=1 nf=1
MMM20_11 Z net55 VDD VDD pch_mac l=30n w=220.0n m=1 nf=1
MMM20_12 Z net55 VDD VDD pch_mac l=30n w=220.0n m=1 nf=1
.ENDS

************************************************************************
* Library Name: BJ_IF_TSMCN28_PHY_SCH_V100
* Cell Name:    phy_spine_u
* View Name:    schematic
************************************************************************

.SUBCKT phy_spine_u D1_DUMP_READY D1_DUMP_READY_ASIC D1_OSC_TM_RES[1]
+ D1_OSC_TM_RES[0] D1_OSC_TM_RES_ASIC[1] D1_OSC_TM_RES_ASIC[0]
+ D1_SPINE_RESET_N D1_SPINE_RESET_N_ASIC D1_STOPWATCH_PERIOD
+ D1_STOPWATCH_PERIOD_ASIC D1_STOPWATCH_RINGO D1_STOPWATCH_RINGO_ASIC
+ D1_TM_REDUMP D1_TM_REDUMP_ASIC D2_DUMP_READY D2_DUMP_READY_ASIC
+ D2_OSC_TM_RES[1] D2_OSC_TM_RES[0] D2_OSC_TM_RES_ASIC[1]
+ D2_OSC_TM_RES_ASIC[0] D2_SPINE_RESET_N D2_SPINE_RESET_N_ASIC
+ D2_STOPWATCH_PERIOD D2_STOPWATCH_PERIOD_ASIC D2_STOPWATCH_RINGO
+ D2_STOPWATCH_RINGO_ASIC D2_TM_REDUMP D2_TM_REDUMP_ASIC D3_DUMP_READY
+ D3_DUMP_READY_ASIC D3_OSC_TM_RES[1] D3_OSC_TM_RES[0] D3_OSC_TM_RES_ASIC[1]
+ D3_OSC_TM_RES_ASIC[0] D3_SPINE_RESET_N D3_SPINE_RESET_N_ASIC
+ D3_STOPWATCH_PERIOD D3_STOPWATCH_PERIOD_ASIC D3_STOPWATCH_RINGO
+ D3_STOPWATCH_RINGO_ASIC D3_TM_REDUMP D3_TM_REDUMP_ASIC DUMP_READY
+ DUMP_READY_ASIC OSC_TM_RES[1] OSC_TM_RES[0] OSC_TM_RES_ASIC[1]
+ OSC_TM_RES_ASIC[0] SPINE_RESET_N SPINE_RESET_N_ASIC STOPWATCH_PERIOD
+ STOPWATCH_PERIOD_ASIC STOPWATCH_RINGO STOPWATCH_RINGO_ASIC TM_REDUMP
+ TM_REDUMP_ASIC TSV_TM_88_1[87] TSV_TM_88_1[86] TSV_TM_88_1[85]
+ TSV_TM_88_1[84] TSV_TM_88_1[83] TSV_TM_88_1[82] TSV_TM_88_1[81]
+ TSV_TM_88_1[80] TSV_TM_88_1[79] TSV_TM_88_1[78] TSV_TM_88_1[77]
+ TSV_TM_88_1[76] TSV_TM_88_1[75] TSV_TM_88_1[74] TSV_TM_88_1[73]
+ TSV_TM_88_1[72] TSV_TM_88_1[71] TSV_TM_88_1[70] TSV_TM_88_1[69]
+ TSV_TM_88_1[68] TSV_TM_88_1[67] TSV_TM_88_1[66] TSV_TM_88_1[65]
+ TSV_TM_88_1[64] TSV_TM_88_1[63] TSV_TM_88_1[62] TSV_TM_88_1[61]
+ TSV_TM_88_1[60] TSV_TM_88_1[59] TSV_TM_88_1[58] TSV_TM_88_1[57]
+ TSV_TM_88_1[56] TSV_TM_88_1[55] TSV_TM_88_1[54] TSV_TM_88_1[53]
+ TSV_TM_88_1[52] TSV_TM_88_1[51] TSV_TM_88_1[50] TSV_TM_88_1[49]
+ TSV_TM_88_1[48] TSV_TM_88_1[47] TSV_TM_88_1[46] TSV_TM_88_1[45]
+ TSV_TM_88_1[44] TSV_TM_88_1[43] TSV_TM_88_1[42] TSV_TM_88_1[41]
+ TSV_TM_88_1[40] TSV_TM_88_1[39] TSV_TM_88_1[38] TSV_TM_88_1[37]
+ TSV_TM_88_1[36] TSV_TM_88_1[35] TSV_TM_88_1[34] TSV_TM_88_1[33]
+ TSV_TM_88_1[32] TSV_TM_88_1[31] TSV_TM_88_1[30] TSV_TM_88_1[29]
+ TSV_TM_88_1[28] TSV_TM_88_1[27] TSV_TM_88_1[26] TSV_TM_88_1[25]
+ TSV_TM_88_1[24] TSV_TM_88_1[23] TSV_TM_88_1[22] TSV_TM_88_1[21]
+ TSV_TM_88_1[20] TSV_TM_88_1[19] TSV_TM_88_1[18] TSV_TM_88_1[17]
+ TSV_TM_88_1[16] TSV_TM_88_1[15] TSV_TM_88_1[14] TSV_TM_88_1[13]
+ TSV_TM_88_1[12] TSV_TM_88_1[11] TSV_TM_88_1[10] TSV_TM_88_1[9]
+ TSV_TM_88_1[8] TSV_TM_88_1[7] TSV_TM_88_1[6] TSV_TM_88_1[5] TSV_TM_88_1[4]
+ TSV_TM_88_1[3] TSV_TM_88_1[2] TSV_TM_88_1[1] TSV_TM_88_1[0]
+ TSV_TM_88_1_ASIC[87] TSV_TM_88_1_ASIC[86] TSV_TM_88_1_ASIC[85]
+ TSV_TM_88_1_ASIC[84] TSV_TM_88_1_ASIC[83] TSV_TM_88_1_ASIC[82]
+ TSV_TM_88_1_ASIC[81] TSV_TM_88_1_ASIC[80] TSV_TM_88_1_ASIC[79]
+ TSV_TM_88_1_ASIC[78] TSV_TM_88_1_ASIC[77] TSV_TM_88_1_ASIC[76]
+ TSV_TM_88_1_ASIC[75] TSV_TM_88_1_ASIC[74] TSV_TM_88_1_ASIC[73]
+ TSV_TM_88_1_ASIC[72] TSV_TM_88_1_ASIC[71] TSV_TM_88_1_ASIC[70]
+ TSV_TM_88_1_ASIC[69] TSV_TM_88_1_ASIC[68] TSV_TM_88_1_ASIC[67]
+ TSV_TM_88_1_ASIC[66] TSV_TM_88_1_ASIC[65] TSV_TM_88_1_ASIC[64]
+ TSV_TM_88_1_ASIC[63] TSV_TM_88_1_ASIC[62] TSV_TM_88_1_ASIC[61]
+ TSV_TM_88_1_ASIC[60] TSV_TM_88_1_ASIC[59] TSV_TM_88_1_ASIC[58]
+ TSV_TM_88_1_ASIC[57] TSV_TM_88_1_ASIC[56] TSV_TM_88_1_ASIC[55]
+ TSV_TM_88_1_ASIC[54] TSV_TM_88_1_ASIC[53] TSV_TM_88_1_ASIC[52]
+ TSV_TM_88_1_ASIC[51] TSV_TM_88_1_ASIC[50] TSV_TM_88_1_ASIC[49]
+ TSV_TM_88_1_ASIC[48] TSV_TM_88_1_ASIC[47] TSV_TM_88_1_ASIC[46]
+ TSV_TM_88_1_ASIC[45] TSV_TM_88_1_ASIC[44] TSV_TM_88_1_ASIC[43]
+ TSV_TM_88_1_ASIC[42] TSV_TM_88_1_ASIC[41] TSV_TM_88_1_ASIC[40]
+ TSV_TM_88_1_ASIC[39] TSV_TM_88_1_ASIC[38] TSV_TM_88_1_ASIC[37]
+ TSV_TM_88_1_ASIC[36] TSV_TM_88_1_ASIC[35] TSV_TM_88_1_ASIC[34]
+ TSV_TM_88_1_ASIC[33] TSV_TM_88_1_ASIC[32] TSV_TM_88_1_ASIC[31]
+ TSV_TM_88_1_ASIC[30] TSV_TM_88_1_ASIC[29] TSV_TM_88_1_ASIC[28]
+ TSV_TM_88_1_ASIC[27] TSV_TM_88_1_ASIC[26] TSV_TM_88_1_ASIC[25]
+ TSV_TM_88_1_ASIC[24] TSV_TM_88_1_ASIC[23] TSV_TM_88_1_ASIC[22]
+ TSV_TM_88_1_ASIC[21] TSV_TM_88_1_ASIC[20] TSV_TM_88_1_ASIC[19]
+ TSV_TM_88_1_ASIC[18] TSV_TM_88_1_ASIC[17] TSV_TM_88_1_ASIC[16]
+ TSV_TM_88_1_ASIC[15] TSV_TM_88_1_ASIC[14] TSV_TM_88_1_ASIC[13]
+ TSV_TM_88_1_ASIC[12] TSV_TM_88_1_ASIC[11] TSV_TM_88_1_ASIC[10]
+ TSV_TM_88_1_ASIC[9] TSV_TM_88_1_ASIC[8] TSV_TM_88_1_ASIC[7]
+ TSV_TM_88_1_ASIC[6] TSV_TM_88_1_ASIC[5] TSV_TM_88_1_ASIC[4]
+ TSV_TM_88_1_ASIC[3] TSV_TM_88_1_ASIC[2] TSV_TM_88_1_ASIC[1]
+ TSV_TM_88_1_ASIC[0] TSV_TM_332_205[127] TSV_TM_332_205[126]
+ TSV_TM_332_205[125] TSV_TM_332_205[124] TSV_TM_332_205[123]
+ TSV_TM_332_205[122] TSV_TM_332_205[121] TSV_TM_332_205[120]
+ TSV_TM_332_205[119] TSV_TM_332_205[118] TSV_TM_332_205[117]
+ TSV_TM_332_205[116] TSV_TM_332_205[115] TSV_TM_332_205[114]
+ TSV_TM_332_205[113] TSV_TM_332_205[112] TSV_TM_332_205[111]
+ TSV_TM_332_205[110] TSV_TM_332_205[109] TSV_TM_332_205[108]
+ TSV_TM_332_205[107] TSV_TM_332_205[106] TSV_TM_332_205[105]
+ TSV_TM_332_205[104] TSV_TM_332_205[103] TSV_TM_332_205[102]
+ TSV_TM_332_205[101] TSV_TM_332_205[100] TSV_TM_332_205[99]
+ TSV_TM_332_205[98] TSV_TM_332_205[97] TSV_TM_332_205[96] TSV_TM_332_205[95]
+ TSV_TM_332_205[94] TSV_TM_332_205[93] TSV_TM_332_205[92] TSV_TM_332_205[91]
+ TSV_TM_332_205[90] TSV_TM_332_205[89] TSV_TM_332_205[88] TSV_TM_332_205[87]
+ TSV_TM_332_205[86] TSV_TM_332_205[85] TSV_TM_332_205[84] TSV_TM_332_205[83]
+ TSV_TM_332_205[82] TSV_TM_332_205[81] TSV_TM_332_205[80] TSV_TM_332_205[79]
+ TSV_TM_332_205[78] TSV_TM_332_205[77] TSV_TM_332_205[76] TSV_TM_332_205[75]
+ TSV_TM_332_205[74] TSV_TM_332_205[73] TSV_TM_332_205[72] TSV_TM_332_205[71]
+ TSV_TM_332_205[70] TSV_TM_332_205[69] TSV_TM_332_205[68] TSV_TM_332_205[67]
+ TSV_TM_332_205[66] TSV_TM_332_205[65] TSV_TM_332_205[64] TSV_TM_332_205[63]
+ TSV_TM_332_205[62] TSV_TM_332_205[61] TSV_TM_332_205[60] TSV_TM_332_205[59]
+ TSV_TM_332_205[58] TSV_TM_332_205[57] TSV_TM_332_205[56] TSV_TM_332_205[55]
+ TSV_TM_332_205[54] TSV_TM_332_205[53] TSV_TM_332_205[52] TSV_TM_332_205[51]
+ TSV_TM_332_205[50] TSV_TM_332_205[49] TSV_TM_332_205[48] TSV_TM_332_205[47]
+ TSV_TM_332_205[46] TSV_TM_332_205[45] TSV_TM_332_205[44] TSV_TM_332_205[43]
+ TSV_TM_332_205[42] TSV_TM_332_205[41] TSV_TM_332_205[40] TSV_TM_332_205[39]
+ TSV_TM_332_205[38] TSV_TM_332_205[37] TSV_TM_332_205[36] TSV_TM_332_205[35]
+ TSV_TM_332_205[34] TSV_TM_332_205[33] TSV_TM_332_205[32] TSV_TM_332_205[31]
+ TSV_TM_332_205[30] TSV_TM_332_205[29] TSV_TM_332_205[28] TSV_TM_332_205[27]
+ TSV_TM_332_205[26] TSV_TM_332_205[25] TSV_TM_332_205[24] TSV_TM_332_205[23]
+ TSV_TM_332_205[22] TSV_TM_332_205[21] TSV_TM_332_205[20] TSV_TM_332_205[19]
+ TSV_TM_332_205[18] TSV_TM_332_205[17] TSV_TM_332_205[16] TSV_TM_332_205[15]
+ TSV_TM_332_205[14] TSV_TM_332_205[13] TSV_TM_332_205[12] TSV_TM_332_205[11]
+ TSV_TM_332_205[10] TSV_TM_332_205[9] TSV_TM_332_205[8] TSV_TM_332_205[7]
+ TSV_TM_332_205[6] TSV_TM_332_205[5] TSV_TM_332_205[4] TSV_TM_332_205[3]
+ TSV_TM_332_205[2] TSV_TM_332_205[1] TSV_TM_332_205[0]
+ TSV_TM_332_205_ASIC[127] TSV_TM_332_205_ASIC[126] TSV_TM_332_205_ASIC[125]
+ TSV_TM_332_205_ASIC[124] TSV_TM_332_205_ASIC[123] TSV_TM_332_205_ASIC[122]
+ TSV_TM_332_205_ASIC[121] TSV_TM_332_205_ASIC[120] TSV_TM_332_205_ASIC[119]
+ TSV_TM_332_205_ASIC[118] TSV_TM_332_205_ASIC[117] TSV_TM_332_205_ASIC[116]
+ TSV_TM_332_205_ASIC[115] TSV_TM_332_205_ASIC[114] TSV_TM_332_205_ASIC[113]
+ TSV_TM_332_205_ASIC[112] TSV_TM_332_205_ASIC[111] TSV_TM_332_205_ASIC[110]
+ TSV_TM_332_205_ASIC[109] TSV_TM_332_205_ASIC[108] TSV_TM_332_205_ASIC[107]
+ TSV_TM_332_205_ASIC[106] TSV_TM_332_205_ASIC[105] TSV_TM_332_205_ASIC[104]
+ TSV_TM_332_205_ASIC[103] TSV_TM_332_205_ASIC[102] TSV_TM_332_205_ASIC[101]
+ TSV_TM_332_205_ASIC[100] TSV_TM_332_205_ASIC[99] TSV_TM_332_205_ASIC[98]
+ TSV_TM_332_205_ASIC[97] TSV_TM_332_205_ASIC[96] TSV_TM_332_205_ASIC[95]
+ TSV_TM_332_205_ASIC[94] TSV_TM_332_205_ASIC[93] TSV_TM_332_205_ASIC[92]
+ TSV_TM_332_205_ASIC[91] TSV_TM_332_205_ASIC[90] TSV_TM_332_205_ASIC[89]
+ TSV_TM_332_205_ASIC[88] TSV_TM_332_205_ASIC[87] TSV_TM_332_205_ASIC[86]
+ TSV_TM_332_205_ASIC[85] TSV_TM_332_205_ASIC[84] TSV_TM_332_205_ASIC[83]
+ TSV_TM_332_205_ASIC[82] TSV_TM_332_205_ASIC[81] TSV_TM_332_205_ASIC[80]
+ TSV_TM_332_205_ASIC[79] TSV_TM_332_205_ASIC[78] TSV_TM_332_205_ASIC[77]
+ TSV_TM_332_205_ASIC[76] TSV_TM_332_205_ASIC[75] TSV_TM_332_205_ASIC[74]
+ TSV_TM_332_205_ASIC[73] TSV_TM_332_205_ASIC[72] TSV_TM_332_205_ASIC[71]
+ TSV_TM_332_205_ASIC[70] TSV_TM_332_205_ASIC[69] TSV_TM_332_205_ASIC[68]
+ TSV_TM_332_205_ASIC[67] TSV_TM_332_205_ASIC[66] TSV_TM_332_205_ASIC[65]
+ TSV_TM_332_205_ASIC[64] TSV_TM_332_205_ASIC[63] TSV_TM_332_205_ASIC[62]
+ TSV_TM_332_205_ASIC[61] TSV_TM_332_205_ASIC[60] TSV_TM_332_205_ASIC[59]
+ TSV_TM_332_205_ASIC[58] TSV_TM_332_205_ASIC[57] TSV_TM_332_205_ASIC[56]
+ TSV_TM_332_205_ASIC[55] TSV_TM_332_205_ASIC[54] TSV_TM_332_205_ASIC[53]
+ TSV_TM_332_205_ASIC[52] TSV_TM_332_205_ASIC[51] TSV_TM_332_205_ASIC[50]
+ TSV_TM_332_205_ASIC[49] TSV_TM_332_205_ASIC[48] TSV_TM_332_205_ASIC[47]
+ TSV_TM_332_205_ASIC[46] TSV_TM_332_205_ASIC[45] TSV_TM_332_205_ASIC[44]
+ TSV_TM_332_205_ASIC[43] TSV_TM_332_205_ASIC[42] TSV_TM_332_205_ASIC[41]
+ TSV_TM_332_205_ASIC[40] TSV_TM_332_205_ASIC[39] TSV_TM_332_205_ASIC[38]
+ TSV_TM_332_205_ASIC[37] TSV_TM_332_205_ASIC[36] TSV_TM_332_205_ASIC[35]
+ TSV_TM_332_205_ASIC[34] TSV_TM_332_205_ASIC[33] TSV_TM_332_205_ASIC[32]
+ TSV_TM_332_205_ASIC[31] TSV_TM_332_205_ASIC[30] TSV_TM_332_205_ASIC[29]
+ TSV_TM_332_205_ASIC[28] TSV_TM_332_205_ASIC[27] TSV_TM_332_205_ASIC[26]
+ TSV_TM_332_205_ASIC[25] TSV_TM_332_205_ASIC[24] TSV_TM_332_205_ASIC[23]
+ TSV_TM_332_205_ASIC[22] TSV_TM_332_205_ASIC[21] TSV_TM_332_205_ASIC[20]
+ TSV_TM_332_205_ASIC[19] TSV_TM_332_205_ASIC[18] TSV_TM_332_205_ASIC[17]
+ TSV_TM_332_205_ASIC[16] TSV_TM_332_205_ASIC[15] TSV_TM_332_205_ASIC[14]
+ TSV_TM_332_205_ASIC[13] TSV_TM_332_205_ASIC[12] TSV_TM_332_205_ASIC[11]
+ TSV_TM_332_205_ASIC[10] TSV_TM_332_205_ASIC[9] TSV_TM_332_205_ASIC[8]
+ TSV_TM_332_205_ASIC[7] TSV_TM_332_205_ASIC[6] TSV_TM_332_205_ASIC[5]
+ TSV_TM_332_205_ASIC[4] TSV_TM_332_205_ASIC[3] TSV_TM_332_205_ASIC[2]
+ TSV_TM_332_205_ASIC[1] TSV_TM_332_205_ASIC[0] VMON ls_en_asic vdd vdd_array
+ vss vss_array
*.PININFO D1_DUMP_READY:I D1_OSC_TM_RES[1]:I D1_OSC_TM_RES[0]:I
*.PININFO D1_SPINE_RESET_N_ASIC:I D1_STOPWATCH_PERIOD_ASIC:I
*.PININFO D1_STOPWATCH_RINGO:I D1_TM_REDUMP_ASIC:I D2_DUMP_READY:I
*.PININFO D2_OSC_TM_RES[1]:I D2_OSC_TM_RES[0]:I D2_SPINE_RESET_N_ASIC:I
*.PININFO D2_STOPWATCH_PERIOD_ASIC:I D2_STOPWATCH_RINGO:I D2_TM_REDUMP_ASIC:I
*.PININFO D3_DUMP_READY:I D3_OSC_TM_RES[1]:I D3_OSC_TM_RES[0]:I
*.PININFO D3_SPINE_RESET_N_ASIC:I D3_STOPWATCH_PERIOD_ASIC:I
*.PININFO D3_STOPWATCH_RINGO:I D3_TM_REDUMP_ASIC:I DUMP_READY:I
*.PININFO OSC_TM_RES[1]:I OSC_TM_RES[0]:I SPINE_RESET_N_ASIC:I
*.PININFO STOPWATCH_PERIOD_ASIC:I STOPWATCH_RINGO:I TM_REDUMP_ASIC:I
*.PININFO TSV_TM_88_1_ASIC[87]:I TSV_TM_88_1_ASIC[86]:I TSV_TM_88_1_ASIC[85]:I
*.PININFO TSV_TM_88_1_ASIC[84]:I TSV_TM_88_1_ASIC[83]:I TSV_TM_88_1_ASIC[82]:I
*.PININFO TSV_TM_88_1_ASIC[81]:I TSV_TM_88_1_ASIC[80]:I TSV_TM_88_1_ASIC[79]:I
*.PININFO TSV_TM_88_1_ASIC[78]:I TSV_TM_88_1_ASIC[77]:I TSV_TM_88_1_ASIC[76]:I
*.PININFO TSV_TM_88_1_ASIC[75]:I TSV_TM_88_1_ASIC[74]:I TSV_TM_88_1_ASIC[73]:I
*.PININFO TSV_TM_88_1_ASIC[72]:I TSV_TM_88_1_ASIC[71]:I TSV_TM_88_1_ASIC[70]:I
*.PININFO TSV_TM_88_1_ASIC[69]:I TSV_TM_88_1_ASIC[68]:I TSV_TM_88_1_ASIC[67]:I
*.PININFO TSV_TM_88_1_ASIC[66]:I TSV_TM_88_1_ASIC[65]:I TSV_TM_88_1_ASIC[64]:I
*.PININFO TSV_TM_88_1_ASIC[63]:I TSV_TM_88_1_ASIC[62]:I TSV_TM_88_1_ASIC[61]:I
*.PININFO TSV_TM_88_1_ASIC[60]:I TSV_TM_88_1_ASIC[59]:I TSV_TM_88_1_ASIC[58]:I
*.PININFO TSV_TM_88_1_ASIC[57]:I TSV_TM_88_1_ASIC[56]:I TSV_TM_88_1_ASIC[55]:I
*.PININFO TSV_TM_88_1_ASIC[54]:I TSV_TM_88_1_ASIC[53]:I TSV_TM_88_1_ASIC[52]:I
*.PININFO TSV_TM_88_1_ASIC[51]:I TSV_TM_88_1_ASIC[50]:I TSV_TM_88_1_ASIC[49]:I
*.PININFO TSV_TM_88_1_ASIC[48]:I TSV_TM_88_1_ASIC[47]:I TSV_TM_88_1_ASIC[46]:I
*.PININFO TSV_TM_88_1_ASIC[45]:I TSV_TM_88_1_ASIC[44]:I TSV_TM_88_1_ASIC[43]:I
*.PININFO TSV_TM_88_1_ASIC[42]:I TSV_TM_88_1_ASIC[41]:I TSV_TM_88_1_ASIC[40]:I
*.PININFO TSV_TM_88_1_ASIC[39]:I TSV_TM_88_1_ASIC[38]:I TSV_TM_88_1_ASIC[37]:I
*.PININFO TSV_TM_88_1_ASIC[36]:I TSV_TM_88_1_ASIC[35]:I TSV_TM_88_1_ASIC[34]:I
*.PININFO TSV_TM_88_1_ASIC[33]:I TSV_TM_88_1_ASIC[32]:I TSV_TM_88_1_ASIC[31]:I
*.PININFO TSV_TM_88_1_ASIC[30]:I TSV_TM_88_1_ASIC[29]:I TSV_TM_88_1_ASIC[28]:I
*.PININFO TSV_TM_88_1_ASIC[27]:I TSV_TM_88_1_ASIC[26]:I TSV_TM_88_1_ASIC[25]:I
*.PININFO TSV_TM_88_1_ASIC[24]:I TSV_TM_88_1_ASIC[23]:I TSV_TM_88_1_ASIC[22]:I
*.PININFO TSV_TM_88_1_ASIC[21]:I TSV_TM_88_1_ASIC[20]:I TSV_TM_88_1_ASIC[19]:I
*.PININFO TSV_TM_88_1_ASIC[18]:I TSV_TM_88_1_ASIC[17]:I TSV_TM_88_1_ASIC[16]:I
*.PININFO TSV_TM_88_1_ASIC[15]:I TSV_TM_88_1_ASIC[14]:I TSV_TM_88_1_ASIC[13]:I
*.PININFO TSV_TM_88_1_ASIC[12]:I TSV_TM_88_1_ASIC[11]:I TSV_TM_88_1_ASIC[10]:I
*.PININFO TSV_TM_88_1_ASIC[9]:I TSV_TM_88_1_ASIC[8]:I TSV_TM_88_1_ASIC[7]:I
*.PININFO TSV_TM_88_1_ASIC[6]:I TSV_TM_88_1_ASIC[5]:I TSV_TM_88_1_ASIC[4]:I
*.PININFO TSV_TM_88_1_ASIC[3]:I TSV_TM_88_1_ASIC[2]:I TSV_TM_88_1_ASIC[1]:I
*.PININFO TSV_TM_88_1_ASIC[0]:I TSV_TM_332_205_ASIC[127]:I
*.PININFO TSV_TM_332_205_ASIC[126]:I TSV_TM_332_205_ASIC[125]:I
*.PININFO TSV_TM_332_205_ASIC[124]:I TSV_TM_332_205_ASIC[123]:I
*.PININFO TSV_TM_332_205_ASIC[122]:I TSV_TM_332_205_ASIC[121]:I
*.PININFO TSV_TM_332_205_ASIC[120]:I TSV_TM_332_205_ASIC[119]:I
*.PININFO TSV_TM_332_205_ASIC[118]:I TSV_TM_332_205_ASIC[117]:I
*.PININFO TSV_TM_332_205_ASIC[116]:I TSV_TM_332_205_ASIC[115]:I
*.PININFO TSV_TM_332_205_ASIC[114]:I TSV_TM_332_205_ASIC[113]:I
*.PININFO TSV_TM_332_205_ASIC[112]:I TSV_TM_332_205_ASIC[111]:I
*.PININFO TSV_TM_332_205_ASIC[110]:I TSV_TM_332_205_ASIC[109]:I
*.PININFO TSV_TM_332_205_ASIC[108]:I TSV_TM_332_205_ASIC[107]:I
*.PININFO TSV_TM_332_205_ASIC[106]:I TSV_TM_332_205_ASIC[105]:I
*.PININFO TSV_TM_332_205_ASIC[104]:I TSV_TM_332_205_ASIC[103]:I
*.PININFO TSV_TM_332_205_ASIC[102]:I TSV_TM_332_205_ASIC[101]:I
*.PININFO TSV_TM_332_205_ASIC[100]:I TSV_TM_332_205_ASIC[99]:I
*.PININFO TSV_TM_332_205_ASIC[98]:I TSV_TM_332_205_ASIC[97]:I
*.PININFO TSV_TM_332_205_ASIC[96]:I TSV_TM_332_205_ASIC[95]:I
*.PININFO TSV_TM_332_205_ASIC[94]:I TSV_TM_332_205_ASIC[93]:I
*.PININFO TSV_TM_332_205_ASIC[92]:I TSV_TM_332_205_ASIC[91]:I
*.PININFO TSV_TM_332_205_ASIC[90]:I TSV_TM_332_205_ASIC[89]:I
*.PININFO TSV_TM_332_205_ASIC[88]:I TSV_TM_332_205_ASIC[87]:I
*.PININFO TSV_TM_332_205_ASIC[86]:I TSV_TM_332_205_ASIC[85]:I
*.PININFO TSV_TM_332_205_ASIC[84]:I TSV_TM_332_205_ASIC[83]:I
*.PININFO TSV_TM_332_205_ASIC[82]:I TSV_TM_332_205_ASIC[81]:I
*.PININFO TSV_TM_332_205_ASIC[80]:I TSV_TM_332_205_ASIC[79]:I
*.PININFO TSV_TM_332_205_ASIC[78]:I TSV_TM_332_205_ASIC[77]:I
*.PININFO TSV_TM_332_205_ASIC[76]:I TSV_TM_332_205_ASIC[75]:I
*.PININFO TSV_TM_332_205_ASIC[74]:I TSV_TM_332_205_ASIC[73]:I
*.PININFO TSV_TM_332_205_ASIC[72]:I TSV_TM_332_205_ASIC[71]:I
*.PININFO TSV_TM_332_205_ASIC[70]:I TSV_TM_332_205_ASIC[69]:I
*.PININFO TSV_TM_332_205_ASIC[68]:I TSV_TM_332_205_ASIC[67]:I
*.PININFO TSV_TM_332_205_ASIC[66]:I TSV_TM_332_205_ASIC[65]:I
*.PININFO TSV_TM_332_205_ASIC[64]:I TSV_TM_332_205_ASIC[63]:I
*.PININFO TSV_TM_332_205_ASIC[62]:I TSV_TM_332_205_ASIC[61]:I
*.PININFO TSV_TM_332_205_ASIC[60]:I TSV_TM_332_205_ASIC[59]:I
*.PININFO TSV_TM_332_205_ASIC[58]:I TSV_TM_332_205_ASIC[57]:I
*.PININFO TSV_TM_332_205_ASIC[56]:I TSV_TM_332_205_ASIC[55]:I
*.PININFO TSV_TM_332_205_ASIC[54]:I TSV_TM_332_205_ASIC[53]:I
*.PININFO TSV_TM_332_205_ASIC[52]:I TSV_TM_332_205_ASIC[51]:I
*.PININFO TSV_TM_332_205_ASIC[50]:I TSV_TM_332_205_ASIC[49]:I
*.PININFO TSV_TM_332_205_ASIC[48]:I TSV_TM_332_205_ASIC[47]:I
*.PININFO TSV_TM_332_205_ASIC[46]:I TSV_TM_332_205_ASIC[45]:I
*.PININFO TSV_TM_332_205_ASIC[44]:I TSV_TM_332_205_ASIC[43]:I
*.PININFO TSV_TM_332_205_ASIC[42]:I TSV_TM_332_205_ASIC[41]:I
*.PININFO TSV_TM_332_205_ASIC[40]:I TSV_TM_332_205_ASIC[39]:I
*.PININFO TSV_TM_332_205_ASIC[38]:I TSV_TM_332_205_ASIC[37]:I
*.PININFO TSV_TM_332_205_ASIC[36]:I TSV_TM_332_205_ASIC[35]:I
*.PININFO TSV_TM_332_205_ASIC[34]:I TSV_TM_332_205_ASIC[33]:I
*.PININFO TSV_TM_332_205_ASIC[32]:I TSV_TM_332_205_ASIC[31]:I
*.PININFO TSV_TM_332_205_ASIC[30]:I TSV_TM_332_205_ASIC[29]:I
*.PININFO TSV_TM_332_205_ASIC[28]:I TSV_TM_332_205_ASIC[27]:I
*.PININFO TSV_TM_332_205_ASIC[26]:I TSV_TM_332_205_ASIC[25]:I
*.PININFO TSV_TM_332_205_ASIC[24]:I TSV_TM_332_205_ASIC[23]:I
*.PININFO TSV_TM_332_205_ASIC[22]:I TSV_TM_332_205_ASIC[21]:I
*.PININFO TSV_TM_332_205_ASIC[20]:I TSV_TM_332_205_ASIC[19]:I
*.PININFO TSV_TM_332_205_ASIC[18]:I TSV_TM_332_205_ASIC[17]:I
*.PININFO TSV_TM_332_205_ASIC[16]:I TSV_TM_332_205_ASIC[15]:I
*.PININFO TSV_TM_332_205_ASIC[14]:I TSV_TM_332_205_ASIC[13]:I
*.PININFO TSV_TM_332_205_ASIC[12]:I TSV_TM_332_205_ASIC[11]:I
*.PININFO TSV_TM_332_205_ASIC[10]:I TSV_TM_332_205_ASIC[9]:I
*.PININFO TSV_TM_332_205_ASIC[8]:I TSV_TM_332_205_ASIC[7]:I
*.PININFO TSV_TM_332_205_ASIC[6]:I TSV_TM_332_205_ASIC[5]:I
*.PININFO TSV_TM_332_205_ASIC[4]:I TSV_TM_332_205_ASIC[3]:I
*.PININFO TSV_TM_332_205_ASIC[2]:I TSV_TM_332_205_ASIC[1]:I
*.PININFO TSV_TM_332_205_ASIC[0]:I ls_en_asic:I D1_DUMP_READY_ASIC:O
*.PININFO D1_OSC_TM_RES_ASIC[1]:O D1_OSC_TM_RES_ASIC[0]:O D1_SPINE_RESET_N:O
*.PININFO D1_STOPWATCH_PERIOD:O D1_STOPWATCH_RINGO_ASIC:O D1_TM_REDUMP:O
*.PININFO D2_DUMP_READY_ASIC:O D2_OSC_TM_RES_ASIC[1]:O D2_OSC_TM_RES_ASIC[0]:O
*.PININFO D2_SPINE_RESET_N:O D2_STOPWATCH_PERIOD:O D2_STOPWATCH_RINGO_ASIC:O
*.PININFO D2_TM_REDUMP:O D3_DUMP_READY_ASIC:O D3_OSC_TM_RES_ASIC[1]:O
*.PININFO D3_OSC_TM_RES_ASIC[0]:O D3_SPINE_RESET_N:O D3_STOPWATCH_PERIOD:O
*.PININFO D3_STOPWATCH_RINGO_ASIC:O D3_TM_REDUMP:O DUMP_READY_ASIC:O
*.PININFO OSC_TM_RES_ASIC[1]:O OSC_TM_RES_ASIC[0]:O SPINE_RESET_N:O
*.PININFO STOPWATCH_PERIOD:O STOPWATCH_RINGO_ASIC:O TM_REDUMP:O
*.PININFO TSV_TM_88_1[87]:O TSV_TM_88_1[86]:O TSV_TM_88_1[85]:O
*.PININFO TSV_TM_88_1[84]:O TSV_TM_88_1[83]:O TSV_TM_88_1[82]:O
*.PININFO TSV_TM_88_1[81]:O TSV_TM_88_1[80]:O TSV_TM_88_1[79]:O
*.PININFO TSV_TM_88_1[78]:O TSV_TM_88_1[77]:O TSV_TM_88_1[76]:O
*.PININFO TSV_TM_88_1[75]:O TSV_TM_88_1[74]:O TSV_TM_88_1[73]:O
*.PININFO TSV_TM_88_1[72]:O TSV_TM_88_1[71]:O TSV_TM_88_1[70]:O
*.PININFO TSV_TM_88_1[69]:O TSV_TM_88_1[68]:O TSV_TM_88_1[67]:O
*.PININFO TSV_TM_88_1[66]:O TSV_TM_88_1[65]:O TSV_TM_88_1[64]:O
*.PININFO TSV_TM_88_1[63]:O TSV_TM_88_1[62]:O TSV_TM_88_1[61]:O
*.PININFO TSV_TM_88_1[60]:O TSV_TM_88_1[59]:O TSV_TM_88_1[58]:O
*.PININFO TSV_TM_88_1[57]:O TSV_TM_88_1[56]:O TSV_TM_88_1[55]:O
*.PININFO TSV_TM_88_1[54]:O TSV_TM_88_1[53]:O TSV_TM_88_1[52]:O
*.PININFO TSV_TM_88_1[51]:O TSV_TM_88_1[50]:O TSV_TM_88_1[49]:O
*.PININFO TSV_TM_88_1[48]:O TSV_TM_88_1[47]:O TSV_TM_88_1[46]:O
*.PININFO TSV_TM_88_1[45]:O TSV_TM_88_1[44]:O TSV_TM_88_1[43]:O
*.PININFO TSV_TM_88_1[42]:O TSV_TM_88_1[41]:O TSV_TM_88_1[40]:O
*.PININFO TSV_TM_88_1[39]:O TSV_TM_88_1[38]:O TSV_TM_88_1[37]:O
*.PININFO TSV_TM_88_1[36]:O TSV_TM_88_1[35]:O TSV_TM_88_1[34]:O
*.PININFO TSV_TM_88_1[33]:O TSV_TM_88_1[32]:O TSV_TM_88_1[31]:O
*.PININFO TSV_TM_88_1[30]:O TSV_TM_88_1[29]:O TSV_TM_88_1[28]:O
*.PININFO TSV_TM_88_1[27]:O TSV_TM_88_1[26]:O TSV_TM_88_1[25]:O
*.PININFO TSV_TM_88_1[24]:O TSV_TM_88_1[23]:O TSV_TM_88_1[22]:O
*.PININFO TSV_TM_88_1[21]:O TSV_TM_88_1[20]:O TSV_TM_88_1[19]:O
*.PININFO TSV_TM_88_1[18]:O TSV_TM_88_1[17]:O TSV_TM_88_1[16]:O
*.PININFO TSV_TM_88_1[15]:O TSV_TM_88_1[14]:O TSV_TM_88_1[13]:O
*.PININFO TSV_TM_88_1[12]:O TSV_TM_88_1[11]:O TSV_TM_88_1[10]:O
*.PININFO TSV_TM_88_1[9]:O TSV_TM_88_1[8]:O TSV_TM_88_1[7]:O TSV_TM_88_1[6]:O
*.PININFO TSV_TM_88_1[5]:O TSV_TM_88_1[4]:O TSV_TM_88_1[3]:O TSV_TM_88_1[2]:O
*.PININFO TSV_TM_88_1[1]:O TSV_TM_88_1[0]:O TSV_TM_332_205[127]:O
*.PININFO TSV_TM_332_205[126]:O TSV_TM_332_205[125]:O TSV_TM_332_205[124]:O
*.PININFO TSV_TM_332_205[123]:O TSV_TM_332_205[122]:O TSV_TM_332_205[121]:O
*.PININFO TSV_TM_332_205[120]:O TSV_TM_332_205[119]:O TSV_TM_332_205[118]:O
*.PININFO TSV_TM_332_205[117]:O TSV_TM_332_205[116]:O TSV_TM_332_205[115]:O
*.PININFO TSV_TM_332_205[114]:O TSV_TM_332_205[113]:O TSV_TM_332_205[112]:O
*.PININFO TSV_TM_332_205[111]:O TSV_TM_332_205[110]:O TSV_TM_332_205[109]:O
*.PININFO TSV_TM_332_205[108]:O TSV_TM_332_205[107]:O TSV_TM_332_205[106]:O
*.PININFO TSV_TM_332_205[105]:O TSV_TM_332_205[104]:O TSV_TM_332_205[103]:O
*.PININFO TSV_TM_332_205[102]:O TSV_TM_332_205[101]:O TSV_TM_332_205[100]:O
*.PININFO TSV_TM_332_205[99]:O TSV_TM_332_205[98]:O TSV_TM_332_205[97]:O
*.PININFO TSV_TM_332_205[96]:O TSV_TM_332_205[95]:O TSV_TM_332_205[94]:O
*.PININFO TSV_TM_332_205[93]:O TSV_TM_332_205[92]:O TSV_TM_332_205[91]:O
*.PININFO TSV_TM_332_205[90]:O TSV_TM_332_205[89]:O TSV_TM_332_205[88]:O
*.PININFO TSV_TM_332_205[87]:O TSV_TM_332_205[86]:O TSV_TM_332_205[85]:O
*.PININFO TSV_TM_332_205[84]:O TSV_TM_332_205[83]:O TSV_TM_332_205[82]:O
*.PININFO TSV_TM_332_205[81]:O TSV_TM_332_205[80]:O TSV_TM_332_205[79]:O
*.PININFO TSV_TM_332_205[78]:O TSV_TM_332_205[77]:O TSV_TM_332_205[76]:O
*.PININFO TSV_TM_332_205[75]:O TSV_TM_332_205[74]:O TSV_TM_332_205[73]:O
*.PININFO TSV_TM_332_205[72]:O TSV_TM_332_205[71]:O TSV_TM_332_205[70]:O
*.PININFO TSV_TM_332_205[69]:O TSV_TM_332_205[68]:O TSV_TM_332_205[67]:O
*.PININFO TSV_TM_332_205[66]:O TSV_TM_332_205[65]:O TSV_TM_332_205[64]:O
*.PININFO TSV_TM_332_205[63]:O TSV_TM_332_205[62]:O TSV_TM_332_205[61]:O
*.PININFO TSV_TM_332_205[60]:O TSV_TM_332_205[59]:O TSV_TM_332_205[58]:O
*.PININFO TSV_TM_332_205[57]:O TSV_TM_332_205[56]:O TSV_TM_332_205[55]:O
*.PININFO TSV_TM_332_205[54]:O TSV_TM_332_205[53]:O TSV_TM_332_205[52]:O
*.PININFO TSV_TM_332_205[51]:O TSV_TM_332_205[50]:O TSV_TM_332_205[49]:O
*.PININFO TSV_TM_332_205[48]:O TSV_TM_332_205[47]:O TSV_TM_332_205[46]:O
*.PININFO TSV_TM_332_205[45]:O TSV_TM_332_205[44]:O TSV_TM_332_205[43]:O
*.PININFO TSV_TM_332_205[42]:O TSV_TM_332_205[41]:O TSV_TM_332_205[40]:O
*.PININFO TSV_TM_332_205[39]:O TSV_TM_332_205[38]:O TSV_TM_332_205[37]:O
*.PININFO TSV_TM_332_205[36]:O TSV_TM_332_205[35]:O TSV_TM_332_205[34]:O
*.PININFO TSV_TM_332_205[33]:O TSV_TM_332_205[32]:O TSV_TM_332_205[31]:O
*.PININFO TSV_TM_332_205[30]:O TSV_TM_332_205[29]:O TSV_TM_332_205[28]:O
*.PININFO TSV_TM_332_205[27]:O TSV_TM_332_205[26]:O TSV_TM_332_205[25]:O
*.PININFO TSV_TM_332_205[24]:O TSV_TM_332_205[23]:O TSV_TM_332_205[22]:O
*.PININFO TSV_TM_332_205[21]:O TSV_TM_332_205[20]:O TSV_TM_332_205[19]:O
*.PININFO TSV_TM_332_205[18]:O TSV_TM_332_205[17]:O TSV_TM_332_205[16]:O
*.PININFO TSV_TM_332_205[15]:O TSV_TM_332_205[14]:O TSV_TM_332_205[13]:O
*.PININFO TSV_TM_332_205[12]:O TSV_TM_332_205[11]:O TSV_TM_332_205[10]:O
*.PININFO TSV_TM_332_205[9]:O TSV_TM_332_205[8]:O TSV_TM_332_205[7]:O
*.PININFO TSV_TM_332_205[6]:O TSV_TM_332_205[5]:O TSV_TM_332_205[4]:O
*.PININFO TSV_TM_332_205[3]:O TSV_TM_332_205[2]:O TSV_TM_332_205[1]:O
*.PININFO TSV_TM_332_205[0]:O VMON:B vdd:B vdd_array:B vss:B vss_array:B
Xi222 D1_DUMP_READY vdd_array vss_array / physpineu_hb_diode
Xi220 D1_STOPWATCH_RINGO vdd_array vss_array / physpineu_hb_diode
Xi218<1> D1_OSC_TM_RES[1] vdd_array vss_array / physpineu_hb_diode
Xi218<0> D1_OSC_TM_RES[0] vdd_array vss_array / physpineu_hb_diode
Xi261 D3_DUMP_READY vdd_array vss_array / physpineu_hb_diode
Xi259 D3_STOPWATCH_RINGO vdd_array vss_array / physpineu_hb_diode
Xi257<1> D3_OSC_TM_RES[1] vdd_array vss_array / physpineu_hb_diode
Xi257<0> D3_OSC_TM_RES[0] vdd_array vss_array / physpineu_hb_diode
Xi233 D2_DUMP_READY vdd_array vss_array / physpineu_hb_diode
Xi230 D2_STOPWATCH_RINGO vdd_array vss_array / physpineu_hb_diode
Xi131 DUMP_READY vdd_array vss_array / physpineu_hb_diode
Xi228<1> D2_OSC_TM_RES[1] vdd_array vss_array / physpineu_hb_diode
Xi228<0> D2_OSC_TM_RES[0] vdd_array vss_array / physpineu_hb_diode
Xi132 STOPWATCH_RINGO vdd_array vss_array / physpineu_hb_diode
Xi137<1> OSC_TM_RES[1] vdd_array vss_array / physpineu_hb_diode
Xi137<0> OSC_TM_RES[0] vdd_array vss_array / physpineu_hb_diode
Xi289 vdd_array vss_array net847 D3_STOPWATCH_PERIOD vdd vss /
+ physpineu_Levelshift_1p1buf
Xi286 vdd_array vss_array net846 D3_TM_REDUMP vdd vss / physpineu_Levelshift_1p1buf
Xi283 vdd_array vss_array net848 D3_SPINE_RESET_N vdd vss / physpineu_Levelshift_1p1buf
Xi280 vdd_array vss_array net799 D2_STOPWATCH_PERIOD vdd vss /
+ physpineu_Levelshift_1p1buf
Xi277 vdd_array vss_array net798 D2_TM_REDUMP vdd vss / physpineu_Levelshift_1p1buf
Xi274 vdd_array vss_array net800 D2_SPINE_RESET_N vdd vss / physpineu_Levelshift_1p1buf
Xi271 vdd_array vss_array net751 D1_STOPWATCH_PERIOD vdd vss /
+ physpineu_Levelshift_1p1buf
Xi268 vdd_array vss_array net750 D1_TM_REDUMP vdd vss / physpineu_Levelshift_1p1buf
Xi265 vdd_array vss_array net752 D1_SPINE_RESET_N vdd vss / physpineu_Levelshift_1p1buf
Xi140 vdd_array vss_array net262 STOPWATCH_PERIOD vdd vss / physpineu_Levelshift_1p1buf
Xi143 vdd_array vss_array net264 TM_REDUMP vdd vss / physpineu_Levelshift_1p1buf
Xi144 vdd_array vss_array net266 SPINE_RESET_N vdd vss / physpineu_Levelshift_1p1buf
Xi81<17> vdd_array vss_array net281[17] TSV_TM_332_205[125] vdd vss /
+ physpineu_Levelshift_1p1buf
Xi81<16> vdd_array vss_array net281[16] TSV_TM_332_205[124] vdd vss /
+ physpineu_Levelshift_1p1buf
Xi81<15> vdd_array vss_array net281[15] TSV_TM_332_205[123] vdd vss /
+ physpineu_Levelshift_1p1buf
Xi81<14> vdd_array vss_array net281[14] TSV_TM_332_205[122] vdd vss /
+ physpineu_Levelshift_1p1buf
Xi81<13> vdd_array vss_array net281[13] TSV_TM_332_205[121] vdd vss /
+ physpineu_Levelshift_1p1buf
Xi81<12> vdd_array vss_array net281[12] TSV_TM_332_205[120] vdd vss /
+ physpineu_Levelshift_1p1buf
Xi81<11> vdd_array vss_array net281[11] TSV_TM_332_205[119] vdd vss /
+ physpineu_Levelshift_1p1buf
Xi81<10> vdd_array vss_array net281[10] TSV_TM_332_205[118] vdd vss /
+ physpineu_Levelshift_1p1buf
Xi81<9> vdd_array vss_array net281[9] TSV_TM_332_205[117] vdd vss /
+ physpineu_Levelshift_1p1buf
Xi81<8> vdd_array vss_array net281[8] TSV_TM_332_205[116] vdd vss /
+ physpineu_Levelshift_1p1buf
Xi81<7> vdd_array vss_array net281[7] TSV_TM_332_205[115] vdd vss /
+ physpineu_Levelshift_1p1buf
Xi81<6> vdd_array vss_array net281[6] TSV_TM_332_205[114] vdd vss /
+ physpineu_Levelshift_1p1buf
Xi81<5> vdd_array vss_array net281[5] TSV_TM_332_205[113] vdd vss /
+ physpineu_Levelshift_1p1buf
Xi81<4> vdd_array vss_array net281[4] TSV_TM_332_205[112] vdd vss /
+ physpineu_Levelshift_1p1buf
Xi81<3> vdd_array vss_array net281[3] TSV_TM_332_205[111] vdd vss /
+ physpineu_Levelshift_1p1buf
Xi81<2> vdd_array vss_array net281[2] TSV_TM_332_205[110] vdd vss /
+ physpineu_Levelshift_1p1buf
Xi81<1> vdd_array vss_array net281[1] TSV_TM_332_205[109] vdd vss /
+ physpineu_Levelshift_1p1buf
Xi81<0> vdd_array vss_array net281[0] TSV_TM_332_205[108] vdd vss /
+ physpineu_Levelshift_1p1buf
Xi80<17> vdd_array vss_array net282[17] TSV_TM_332_205[107] vdd vss /
+ physpineu_Levelshift_1p1buf
Xi80<16> vdd_array vss_array net282[16] TSV_TM_332_205[106] vdd vss /
+ physpineu_Levelshift_1p1buf
Xi80<15> vdd_array vss_array net282[15] TSV_TM_332_205[105] vdd vss /
+ physpineu_Levelshift_1p1buf
Xi80<14> vdd_array vss_array net282[14] TSV_TM_332_205[104] vdd vss /
+ physpineu_Levelshift_1p1buf
Xi80<13> vdd_array vss_array net282[13] TSV_TM_332_205[103] vdd vss /
+ physpineu_Levelshift_1p1buf
Xi80<12> vdd_array vss_array net282[12] TSV_TM_332_205[102] vdd vss /
+ physpineu_Levelshift_1p1buf
Xi80<11> vdd_array vss_array net282[11] TSV_TM_332_205[101] vdd vss /
+ physpineu_Levelshift_1p1buf
Xi80<10> vdd_array vss_array net282[10] TSV_TM_332_205[100] vdd vss /
+ physpineu_Levelshift_1p1buf
Xi80<9> vdd_array vss_array net282[9] TSV_TM_332_205[99] vdd vss /
+ physpineu_Levelshift_1p1buf
Xi80<8> vdd_array vss_array net282[8] TSV_TM_332_205[98] vdd vss /
+ physpineu_Levelshift_1p1buf
Xi80<7> vdd_array vss_array net282[7] TSV_TM_332_205[97] vdd vss /
+ physpineu_Levelshift_1p1buf
Xi80<6> vdd_array vss_array net282[6] TSV_TM_332_205[96] vdd vss /
+ physpineu_Levelshift_1p1buf
Xi80<5> vdd_array vss_array net282[5] TSV_TM_332_205[95] vdd vss /
+ physpineu_Levelshift_1p1buf
Xi80<4> vdd_array vss_array net282[4] TSV_TM_332_205[94] vdd vss /
+ physpineu_Levelshift_1p1buf
Xi80<3> vdd_array vss_array net282[3] TSV_TM_332_205[93] vdd vss /
+ physpineu_Levelshift_1p1buf
Xi80<2> vdd_array vss_array net282[2] TSV_TM_332_205[92] vdd vss /
+ physpineu_Levelshift_1p1buf
Xi80<1> vdd_array vss_array net282[1] TSV_TM_332_205[91] vdd vss /
+ physpineu_Levelshift_1p1buf
Xi80<0> vdd_array vss_array net282[0] TSV_TM_332_205[90] vdd vss /
+ physpineu_Levelshift_1p1buf
Xi82<1> vdd_array vss_array net280[1] TSV_TM_332_205[127] vdd vss /
+ physpineu_Levelshift_1p1buf
Xi82<0> vdd_array vss_array net280[0] TSV_TM_332_205[126] vdd vss /
+ physpineu_Levelshift_1p1buf
Xi71<17> vdd_array vss_array net286[17] TSV_TM_332_205[89] vdd vss /
+ physpineu_Levelshift_1p1buf
Xi71<16> vdd_array vss_array net286[16] TSV_TM_332_205[88] vdd vss /
+ physpineu_Levelshift_1p1buf
Xi71<15> vdd_array vss_array net286[15] TSV_TM_332_205[87] vdd vss /
+ physpineu_Levelshift_1p1buf
Xi71<14> vdd_array vss_array net286[14] TSV_TM_332_205[86] vdd vss /
+ physpineu_Levelshift_1p1buf
Xi71<13> vdd_array vss_array net286[13] TSV_TM_332_205[85] vdd vss /
+ physpineu_Levelshift_1p1buf
Xi71<12> vdd_array vss_array net286[12] TSV_TM_332_205[84] vdd vss /
+ physpineu_Levelshift_1p1buf
Xi71<11> vdd_array vss_array net286[11] TSV_TM_332_205[83] vdd vss /
+ physpineu_Levelshift_1p1buf
Xi71<10> vdd_array vss_array net286[10] TSV_TM_332_205[82] vdd vss /
+ physpineu_Levelshift_1p1buf
Xi71<9> vdd_array vss_array net286[9] TSV_TM_332_205[81] vdd vss /
+ physpineu_Levelshift_1p1buf
Xi71<8> vdd_array vss_array net286[8] TSV_TM_332_205[80] vdd vss /
+ physpineu_Levelshift_1p1buf
Xi71<7> vdd_array vss_array net286[7] TSV_TM_332_205[79] vdd vss /
+ physpineu_Levelshift_1p1buf
Xi71<6> vdd_array vss_array net286[6] TSV_TM_332_205[78] vdd vss /
+ physpineu_Levelshift_1p1buf
Xi71<5> vdd_array vss_array net286[5] TSV_TM_332_205[77] vdd vss /
+ physpineu_Levelshift_1p1buf
Xi71<4> vdd_array vss_array net286[4] TSV_TM_332_205[76] vdd vss /
+ physpineu_Levelshift_1p1buf
Xi71<3> vdd_array vss_array net286[3] TSV_TM_332_205[75] vdd vss /
+ physpineu_Levelshift_1p1buf
Xi71<2> vdd_array vss_array net286[2] TSV_TM_332_205[74] vdd vss /
+ physpineu_Levelshift_1p1buf
Xi71<1> vdd_array vss_array net286[1] TSV_TM_332_205[73] vdd vss /
+ physpineu_Levelshift_1p1buf
Xi71<0> vdd_array vss_array net286[0] TSV_TM_332_205[72] vdd vss /
+ physpineu_Levelshift_1p1buf
Xi70<17> vdd_array vss_array net283[17] TSV_TM_332_205[71] vdd vss /
+ physpineu_Levelshift_1p1buf
Xi70<16> vdd_array vss_array net283[16] TSV_TM_332_205[70] vdd vss /
+ physpineu_Levelshift_1p1buf
Xi70<15> vdd_array vss_array net283[15] TSV_TM_332_205[69] vdd vss /
+ physpineu_Levelshift_1p1buf
Xi70<14> vdd_array vss_array net283[14] TSV_TM_332_205[68] vdd vss /
+ physpineu_Levelshift_1p1buf
Xi70<13> vdd_array vss_array net283[13] TSV_TM_332_205[67] vdd vss /
+ physpineu_Levelshift_1p1buf
Xi70<12> vdd_array vss_array net283[12] TSV_TM_332_205[66] vdd vss /
+ physpineu_Levelshift_1p1buf
Xi70<11> vdd_array vss_array net283[11] TSV_TM_332_205[65] vdd vss /
+ physpineu_Levelshift_1p1buf
Xi70<10> vdd_array vss_array net283[10] TSV_TM_332_205[64] vdd vss /
+ physpineu_Levelshift_1p1buf
Xi70<9> vdd_array vss_array net283[9] TSV_TM_332_205[63] vdd vss /
+ physpineu_Levelshift_1p1buf
Xi70<8> vdd_array vss_array net283[8] TSV_TM_332_205[62] vdd vss /
+ physpineu_Levelshift_1p1buf
Xi70<7> vdd_array vss_array net283[7] TSV_TM_332_205[61] vdd vss /
+ physpineu_Levelshift_1p1buf
Xi70<6> vdd_array vss_array net283[6] TSV_TM_332_205[60] vdd vss /
+ physpineu_Levelshift_1p1buf
Xi70<5> vdd_array vss_array net283[5] TSV_TM_332_205[59] vdd vss /
+ physpineu_Levelshift_1p1buf
Xi70<4> vdd_array vss_array net283[4] TSV_TM_332_205[58] vdd vss /
+ physpineu_Levelshift_1p1buf
Xi70<3> vdd_array vss_array net283[3] TSV_TM_332_205[57] vdd vss /
+ physpineu_Levelshift_1p1buf
Xi70<2> vdd_array vss_array net283[2] TSV_TM_332_205[56] vdd vss /
+ physpineu_Levelshift_1p1buf
Xi70<1> vdd_array vss_array net283[1] TSV_TM_332_205[55] vdd vss /
+ physpineu_Levelshift_1p1buf
Xi70<0> vdd_array vss_array net283[0] TSV_TM_332_205[54] vdd vss /
+ physpineu_Levelshift_1p1buf
Xi69<17> vdd_array vss_array net284[17] TSV_TM_332_205[53] vdd vss /
+ physpineu_Levelshift_1p1buf
Xi69<16> vdd_array vss_array net284[16] TSV_TM_332_205[52] vdd vss /
+ physpineu_Levelshift_1p1buf
Xi69<15> vdd_array vss_array net284[15] TSV_TM_332_205[51] vdd vss /
+ physpineu_Levelshift_1p1buf
Xi69<14> vdd_array vss_array net284[14] TSV_TM_332_205[50] vdd vss /
+ physpineu_Levelshift_1p1buf
Xi69<13> vdd_array vss_array net284[13] TSV_TM_332_205[49] vdd vss /
+ physpineu_Levelshift_1p1buf
Xi69<12> vdd_array vss_array net284[12] TSV_TM_332_205[48] vdd vss /
+ physpineu_Levelshift_1p1buf
Xi69<11> vdd_array vss_array net284[11] TSV_TM_332_205[47] vdd vss /
+ physpineu_Levelshift_1p1buf
Xi69<10> vdd_array vss_array net284[10] TSV_TM_332_205[46] vdd vss /
+ physpineu_Levelshift_1p1buf
Xi69<9> vdd_array vss_array net284[9] TSV_TM_332_205[45] vdd vss /
+ physpineu_Levelshift_1p1buf
Xi69<8> vdd_array vss_array net284[8] TSV_TM_332_205[44] vdd vss /
+ physpineu_Levelshift_1p1buf
Xi69<7> vdd_array vss_array net284[7] TSV_TM_332_205[43] vdd vss /
+ physpineu_Levelshift_1p1buf
Xi69<6> vdd_array vss_array net284[6] TSV_TM_332_205[42] vdd vss /
+ physpineu_Levelshift_1p1buf
Xi69<5> vdd_array vss_array net284[5] TSV_TM_332_205[41] vdd vss /
+ physpineu_Levelshift_1p1buf
Xi69<4> vdd_array vss_array net284[4] TSV_TM_332_205[40] vdd vss /
+ physpineu_Levelshift_1p1buf
Xi69<3> vdd_array vss_array net284[3] TSV_TM_332_205[39] vdd vss /
+ physpineu_Levelshift_1p1buf
Xi69<2> vdd_array vss_array net284[2] TSV_TM_332_205[38] vdd vss /
+ physpineu_Levelshift_1p1buf
Xi69<1> vdd_array vss_array net284[1] TSV_TM_332_205[37] vdd vss /
+ physpineu_Levelshift_1p1buf
Xi69<0> vdd_array vss_array net284[0] TSV_TM_332_205[36] vdd vss /
+ physpineu_Levelshift_1p1buf
Xi68<17> vdd_array vss_array net285[17] TSV_TM_332_205[35] vdd vss /
+ physpineu_Levelshift_1p1buf
Xi68<16> vdd_array vss_array net285[16] TSV_TM_332_205[34] vdd vss /
+ physpineu_Levelshift_1p1buf
Xi68<15> vdd_array vss_array net285[15] TSV_TM_332_205[33] vdd vss /
+ physpineu_Levelshift_1p1buf
Xi68<14> vdd_array vss_array net285[14] TSV_TM_332_205[32] vdd vss /
+ physpineu_Levelshift_1p1buf
Xi68<13> vdd_array vss_array net285[13] TSV_TM_332_205[31] vdd vss /
+ physpineu_Levelshift_1p1buf
Xi68<12> vdd_array vss_array net285[12] TSV_TM_332_205[30] vdd vss /
+ physpineu_Levelshift_1p1buf
Xi68<11> vdd_array vss_array net285[11] TSV_TM_332_205[29] vdd vss /
+ physpineu_Levelshift_1p1buf
Xi68<10> vdd_array vss_array net285[10] TSV_TM_332_205[28] vdd vss /
+ physpineu_Levelshift_1p1buf
Xi68<9> vdd_array vss_array net285[9] TSV_TM_332_205[27] vdd vss /
+ physpineu_Levelshift_1p1buf
Xi68<8> vdd_array vss_array net285[8] TSV_TM_332_205[26] vdd vss /
+ physpineu_Levelshift_1p1buf
Xi68<7> vdd_array vss_array net285[7] TSV_TM_332_205[25] vdd vss /
+ physpineu_Levelshift_1p1buf
Xi68<6> vdd_array vss_array net285[6] TSV_TM_332_205[24] vdd vss /
+ physpineu_Levelshift_1p1buf
Xi68<5> vdd_array vss_array net285[5] TSV_TM_332_205[23] vdd vss /
+ physpineu_Levelshift_1p1buf
Xi68<4> vdd_array vss_array net285[4] TSV_TM_332_205[22] vdd vss /
+ physpineu_Levelshift_1p1buf
Xi68<3> vdd_array vss_array net285[3] TSV_TM_332_205[21] vdd vss /
+ physpineu_Levelshift_1p1buf
Xi68<2> vdd_array vss_array net285[2] TSV_TM_332_205[20] vdd vss /
+ physpineu_Levelshift_1p1buf
Xi68<1> vdd_array vss_array net285[1] TSV_TM_332_205[19] vdd vss /
+ physpineu_Levelshift_1p1buf
Xi68<0> vdd_array vss_array net285[0] TSV_TM_332_205[18] vdd vss /
+ physpineu_Levelshift_1p1buf
Xi67<17> vdd_array vss_array net287[17] TSV_TM_332_205[17] vdd vss /
+ physpineu_Levelshift_1p1buf
Xi67<16> vdd_array vss_array net287[16] TSV_TM_332_205[16] vdd vss /
+ physpineu_Levelshift_1p1buf
Xi67<15> vdd_array vss_array net287[15] TSV_TM_332_205[15] vdd vss /
+ physpineu_Levelshift_1p1buf
Xi67<14> vdd_array vss_array net287[14] TSV_TM_332_205[14] vdd vss /
+ physpineu_Levelshift_1p1buf
Xi67<13> vdd_array vss_array net287[13] TSV_TM_332_205[13] vdd vss /
+ physpineu_Levelshift_1p1buf
Xi67<12> vdd_array vss_array net287[12] TSV_TM_332_205[12] vdd vss /
+ physpineu_Levelshift_1p1buf
Xi67<11> vdd_array vss_array net287[11] TSV_TM_332_205[11] vdd vss /
+ physpineu_Levelshift_1p1buf
Xi67<10> vdd_array vss_array net287[10] TSV_TM_332_205[10] vdd vss /
+ physpineu_Levelshift_1p1buf
Xi67<9> vdd_array vss_array net287[9] TSV_TM_332_205[9] vdd vss /
+ physpineu_Levelshift_1p1buf
Xi67<8> vdd_array vss_array net287[8] TSV_TM_332_205[8] vdd vss /
+ physpineu_Levelshift_1p1buf
Xi67<7> vdd_array vss_array net287[7] TSV_TM_332_205[7] vdd vss /
+ physpineu_Levelshift_1p1buf
Xi67<6> vdd_array vss_array net287[6] TSV_TM_332_205[6] vdd vss /
+ physpineu_Levelshift_1p1buf
Xi67<5> vdd_array vss_array net287[5] TSV_TM_332_205[5] vdd vss /
+ physpineu_Levelshift_1p1buf
Xi67<4> vdd_array vss_array net287[4] TSV_TM_332_205[4] vdd vss /
+ physpineu_Levelshift_1p1buf
Xi67<3> vdd_array vss_array net287[3] TSV_TM_332_205[3] vdd vss /
+ physpineu_Levelshift_1p1buf
Xi67<2> vdd_array vss_array net287[2] TSV_TM_332_205[2] vdd vss /
+ physpineu_Levelshift_1p1buf
Xi67<1> vdd_array vss_array net287[1] TSV_TM_332_205[1] vdd vss /
+ physpineu_Levelshift_1p1buf
Xi67<0> vdd_array vss_array net287[0] TSV_TM_332_205[0] vdd vss /
+ physpineu_Levelshift_1p1buf
Xi65<17> vdd_array vss_array net289[17] TSV_TM_88_1[71] vdd vss /
+ physpineu_Levelshift_1p1buf
Xi65<16> vdd_array vss_array net289[16] TSV_TM_88_1[70] vdd vss /
+ physpineu_Levelshift_1p1buf
Xi65<15> vdd_array vss_array net289[15] TSV_TM_88_1[69] vdd vss /
+ physpineu_Levelshift_1p1buf
Xi65<14> vdd_array vss_array net289[14] TSV_TM_88_1[68] vdd vss /
+ physpineu_Levelshift_1p1buf
Xi65<13> vdd_array vss_array net289[13] TSV_TM_88_1[67] vdd vss /
+ physpineu_Levelshift_1p1buf
Xi65<12> vdd_array vss_array net289[12] TSV_TM_88_1[66] vdd vss /
+ physpineu_Levelshift_1p1buf
Xi65<11> vdd_array vss_array net289[11] TSV_TM_88_1[65] vdd vss /
+ physpineu_Levelshift_1p1buf
Xi65<10> vdd_array vss_array net289[10] TSV_TM_88_1[64] vdd vss /
+ physpineu_Levelshift_1p1buf
Xi65<9> vdd_array vss_array net289[9] TSV_TM_88_1[63] vdd vss /
+ physpineu_Levelshift_1p1buf
Xi65<8> vdd_array vss_array net289[8] TSV_TM_88_1[62] vdd vss /
+ physpineu_Levelshift_1p1buf
Xi65<7> vdd_array vss_array net289[7] TSV_TM_88_1[61] vdd vss /
+ physpineu_Levelshift_1p1buf
Xi65<6> vdd_array vss_array net289[6] TSV_TM_88_1[60] vdd vss /
+ physpineu_Levelshift_1p1buf
Xi65<5> vdd_array vss_array net289[5] TSV_TM_88_1[59] vdd vss /
+ physpineu_Levelshift_1p1buf
Xi65<4> vdd_array vss_array net289[4] TSV_TM_88_1[58] vdd vss /
+ physpineu_Levelshift_1p1buf
Xi65<3> vdd_array vss_array net289[3] TSV_TM_88_1[57] vdd vss /
+ physpineu_Levelshift_1p1buf
Xi65<2> vdd_array vss_array net289[2] TSV_TM_88_1[56] vdd vss /
+ physpineu_Levelshift_1p1buf
Xi65<1> vdd_array vss_array net289[1] TSV_TM_88_1[55] vdd vss /
+ physpineu_Levelshift_1p1buf
Xi65<0> vdd_array vss_array net289[0] TSV_TM_88_1[54] vdd vss /
+ physpineu_Levelshift_1p1buf
Xi64<17> vdd_array vss_array net290[17] TSV_TM_88_1[53] vdd vss /
+ physpineu_Levelshift_1p1buf
Xi64<16> vdd_array vss_array net290[16] TSV_TM_88_1[52] vdd vss /
+ physpineu_Levelshift_1p1buf
Xi64<15> vdd_array vss_array net290[15] TSV_TM_88_1[51] vdd vss /
+ physpineu_Levelshift_1p1buf
Xi64<14> vdd_array vss_array net290[14] TSV_TM_88_1[50] vdd vss /
+ physpineu_Levelshift_1p1buf
Xi64<13> vdd_array vss_array net290[13] TSV_TM_88_1[49] vdd vss /
+ physpineu_Levelshift_1p1buf
Xi64<12> vdd_array vss_array net290[12] TSV_TM_88_1[48] vdd vss /
+ physpineu_Levelshift_1p1buf
Xi64<11> vdd_array vss_array net290[11] TSV_TM_88_1[47] vdd vss /
+ physpineu_Levelshift_1p1buf
Xi64<10> vdd_array vss_array net290[10] TSV_TM_88_1[46] vdd vss /
+ physpineu_Levelshift_1p1buf
Xi64<9> vdd_array vss_array net290[9] TSV_TM_88_1[45] vdd vss /
+ physpineu_Levelshift_1p1buf
Xi64<8> vdd_array vss_array net290[8] TSV_TM_88_1[44] vdd vss /
+ physpineu_Levelshift_1p1buf
Xi64<7> vdd_array vss_array net290[7] TSV_TM_88_1[43] vdd vss /
+ physpineu_Levelshift_1p1buf
Xi64<6> vdd_array vss_array net290[6] TSV_TM_88_1[42] vdd vss /
+ physpineu_Levelshift_1p1buf
Xi64<5> vdd_array vss_array net290[5] TSV_TM_88_1[41] vdd vss /
+ physpineu_Levelshift_1p1buf
Xi64<4> vdd_array vss_array net290[4] TSV_TM_88_1[40] vdd vss /
+ physpineu_Levelshift_1p1buf
Xi64<3> vdd_array vss_array net290[3] TSV_TM_88_1[39] vdd vss /
+ physpineu_Levelshift_1p1buf
Xi64<2> vdd_array vss_array net290[2] TSV_TM_88_1[38] vdd vss /
+ physpineu_Levelshift_1p1buf
Xi64<1> vdd_array vss_array net290[1] TSV_TM_88_1[37] vdd vss /
+ physpineu_Levelshift_1p1buf
Xi64<0> vdd_array vss_array net290[0] TSV_TM_88_1[36] vdd vss /
+ physpineu_Levelshift_1p1buf
Xi66<15> vdd_array vss_array net288[15] TSV_TM_88_1[87] vdd vss /
+ physpineu_Levelshift_1p1buf
Xi66<14> vdd_array vss_array net288[14] TSV_TM_88_1[86] vdd vss /
+ physpineu_Levelshift_1p1buf
Xi66<13> vdd_array vss_array net288[13] TSV_TM_88_1[85] vdd vss /
+ physpineu_Levelshift_1p1buf
Xi66<12> vdd_array vss_array net288[12] TSV_TM_88_1[84] vdd vss /
+ physpineu_Levelshift_1p1buf
Xi66<11> vdd_array vss_array net288[11] TSV_TM_88_1[83] vdd vss /
+ physpineu_Levelshift_1p1buf
Xi66<10> vdd_array vss_array net288[10] TSV_TM_88_1[82] vdd vss /
+ physpineu_Levelshift_1p1buf
Xi66<9> vdd_array vss_array net288[9] TSV_TM_88_1[81] vdd vss /
+ physpineu_Levelshift_1p1buf
Xi66<8> vdd_array vss_array net288[8] TSV_TM_88_1[80] vdd vss /
+ physpineu_Levelshift_1p1buf
Xi66<7> vdd_array vss_array net288[7] TSV_TM_88_1[79] vdd vss /
+ physpineu_Levelshift_1p1buf
Xi66<6> vdd_array vss_array net288[6] TSV_TM_88_1[78] vdd vss /
+ physpineu_Levelshift_1p1buf
Xi66<5> vdd_array vss_array net288[5] TSV_TM_88_1[77] vdd vss /
+ physpineu_Levelshift_1p1buf
Xi66<4> vdd_array vss_array net288[4] TSV_TM_88_1[76] vdd vss /
+ physpineu_Levelshift_1p1buf
Xi66<3> vdd_array vss_array net288[3] TSV_TM_88_1[75] vdd vss /
+ physpineu_Levelshift_1p1buf
Xi66<2> vdd_array vss_array net288[2] TSV_TM_88_1[74] vdd vss /
+ physpineu_Levelshift_1p1buf
Xi66<1> vdd_array vss_array net288[1] TSV_TM_88_1[73] vdd vss /
+ physpineu_Levelshift_1p1buf
Xi66<0> vdd_array vss_array net288[0] TSV_TM_88_1[72] vdd vss /
+ physpineu_Levelshift_1p1buf
Xi45<17> vdd_array vss_array net291[17] TSV_TM_88_1[35] vdd vss /
+ physpineu_Levelshift_1p1buf
Xi45<16> vdd_array vss_array net291[16] TSV_TM_88_1[34] vdd vss /
+ physpineu_Levelshift_1p1buf
Xi45<15> vdd_array vss_array net291[15] TSV_TM_88_1[33] vdd vss /
+ physpineu_Levelshift_1p1buf
Xi45<14> vdd_array vss_array net291[14] TSV_TM_88_1[32] vdd vss /
+ physpineu_Levelshift_1p1buf
Xi45<13> vdd_array vss_array net291[13] TSV_TM_88_1[31] vdd vss /
+ physpineu_Levelshift_1p1buf
Xi45<12> vdd_array vss_array net291[12] TSV_TM_88_1[30] vdd vss /
+ physpineu_Levelshift_1p1buf
Xi45<11> vdd_array vss_array net291[11] TSV_TM_88_1[29] vdd vss /
+ physpineu_Levelshift_1p1buf
Xi45<10> vdd_array vss_array net291[10] TSV_TM_88_1[28] vdd vss /
+ physpineu_Levelshift_1p1buf
Xi45<9> vdd_array vss_array net291[9] TSV_TM_88_1[27] vdd vss /
+ physpineu_Levelshift_1p1buf
Xi45<8> vdd_array vss_array net291[8] TSV_TM_88_1[26] vdd vss /
+ physpineu_Levelshift_1p1buf
Xi45<7> vdd_array vss_array net291[7] TSV_TM_88_1[25] vdd vss /
+ physpineu_Levelshift_1p1buf
Xi45<6> vdd_array vss_array net291[6] TSV_TM_88_1[24] vdd vss /
+ physpineu_Levelshift_1p1buf
Xi45<5> vdd_array vss_array net291[5] TSV_TM_88_1[23] vdd vss /
+ physpineu_Levelshift_1p1buf
Xi45<4> vdd_array vss_array net291[4] TSV_TM_88_1[22] vdd vss /
+ physpineu_Levelshift_1p1buf
Xi45<3> vdd_array vss_array net291[3] TSV_TM_88_1[21] vdd vss /
+ physpineu_Levelshift_1p1buf
Xi45<2> vdd_array vss_array net291[2] TSV_TM_88_1[20] vdd vss /
+ physpineu_Levelshift_1p1buf
Xi45<1> vdd_array vss_array net291[1] TSV_TM_88_1[19] vdd vss /
+ physpineu_Levelshift_1p1buf
Xi45<0> vdd_array vss_array net291[0] TSV_TM_88_1[18] vdd vss /
+ physpineu_Levelshift_1p1buf
Xlv_tm_gen<17> vdd_array vss_array net292[17] TSV_TM_88_1[17] vdd vss /
+ physpineu_Levelshift_1p1buf
Xlv_tm_gen<16> vdd_array vss_array net292[16] TSV_TM_88_1[16] vdd vss /
+ physpineu_Levelshift_1p1buf
Xlv_tm_gen<15> vdd_array vss_array net292[15] TSV_TM_88_1[15] vdd vss /
+ physpineu_Levelshift_1p1buf
Xlv_tm_gen<14> vdd_array vss_array net292[14] TSV_TM_88_1[14] vdd vss /
+ physpineu_Levelshift_1p1buf
Xlv_tm_gen<13> vdd_array vss_array net292[13] TSV_TM_88_1[13] vdd vss /
+ physpineu_Levelshift_1p1buf
Xlv_tm_gen<12> vdd_array vss_array net292[12] TSV_TM_88_1[12] vdd vss /
+ physpineu_Levelshift_1p1buf
Xlv_tm_gen<11> vdd_array vss_array net292[11] TSV_TM_88_1[11] vdd vss /
+ physpineu_Levelshift_1p1buf
Xlv_tm_gen<10> vdd_array vss_array net292[10] TSV_TM_88_1[10] vdd vss /
+ physpineu_Levelshift_1p1buf
Xlv_tm_gen<9> vdd_array vss_array net292[9] TSV_TM_88_1[9] vdd vss /
+ physpineu_Levelshift_1p1buf
Xlv_tm_gen<8> vdd_array vss_array net292[8] TSV_TM_88_1[8] vdd vss /
+ physpineu_Levelshift_1p1buf
Xlv_tm_gen<7> vdd_array vss_array net292[7] TSV_TM_88_1[7] vdd vss /
+ physpineu_Levelshift_1p1buf
Xlv_tm_gen<6> vdd_array vss_array net292[6] TSV_TM_88_1[6] vdd vss /
+ physpineu_Levelshift_1p1buf
Xlv_tm_gen<5> vdd_array vss_array net292[5] TSV_TM_88_1[5] vdd vss /
+ physpineu_Levelshift_1p1buf
Xlv_tm_gen<4> vdd_array vss_array net292[4] TSV_TM_88_1[4] vdd vss /
+ physpineu_Levelshift_1p1buf
Xlv_tm_gen<3> vdd_array vss_array net292[3] TSV_TM_88_1[3] vdd vss /
+ physpineu_Levelshift_1p1buf
Xlv_tm_gen<2> vdd_array vss_array net292[2] TSV_TM_88_1[2] vdd vss /
+ physpineu_Levelshift_1p1buf
Xlv_tm_gen<1> vdd_array vss_array net292[1] TSV_TM_88_1[1] vdd vss /
+ physpineu_Levelshift_1p1buf
Xlv_tm_gen<0> vdd_array vss_array net292[0] TSV_TM_88_1[0] vdd vss /
+ physpineu_Levelshift_1p1buf
Xi285 D3_TM_REDUMP_ASIC ls_en_asic_buf12 vdd vss net825 / physpineu_ND2D2BWP7T30P140
Xi284 D3_STOPWATCH_PERIOD_ASIC ls_en_asic_buf12 vdd vss net826 /
+ physpineu_ND2D2BWP7T30P140
Xi281 D3_SPINE_RESET_N_ASIC ls_en_asic_buf12 vdd vss net827 / physpineu_ND2D2BWP7T30P140
Xi276 D2_TM_REDUMP_ASIC ls_en_asic_buf12 vdd vss net779 / physpineu_ND2D2BWP7T30P140
Xi275 D2_STOPWATCH_PERIOD_ASIC ls_en_asic_buf12 vdd vss net778 /
+ physpineu_ND2D2BWP7T30P140
Xi272 D2_SPINE_RESET_N_ASIC ls_en_asic_buf12 vdd vss net777 / physpineu_ND2D2BWP7T30P140
Xi267 D1_TM_REDUMP_ASIC ls_en_asic_buf12 vdd vss net729 / physpineu_ND2D2BWP7T30P140
Xi266 D1_STOPWATCH_PERIOD_ASIC ls_en_asic_buf12 vdd vss net730 /
+ physpineu_ND2D2BWP7T30P140
Xi263 D1_SPINE_RESET_N_ASIC ls_en_asic_buf12 vdd vss net731 / physpineu_ND2D2BWP7T30P140
Xi52<15> TSV_TM_88_1_ASIC[87] ls_en_asic_buf4 vdd vss net275[15] /
+ physpineu_ND2D2BWP7T30P140
Xi52<14> TSV_TM_88_1_ASIC[86] ls_en_asic_buf4 vdd vss net275[14] /
+ physpineu_ND2D2BWP7T30P140
Xi52<13> TSV_TM_88_1_ASIC[85] ls_en_asic_buf4 vdd vss net275[13] /
+ physpineu_ND2D2BWP7T30P140
Xi52<12> TSV_TM_88_1_ASIC[84] ls_en_asic_buf4 vdd vss net275[12] /
+ physpineu_ND2D2BWP7T30P140
Xi52<11> TSV_TM_88_1_ASIC[83] ls_en_asic_buf4 vdd vss net275[11] /
+ physpineu_ND2D2BWP7T30P140
Xi52<10> TSV_TM_88_1_ASIC[82] ls_en_asic_buf4 vdd vss net275[10] /
+ physpineu_ND2D2BWP7T30P140
Xi52<9> TSV_TM_88_1_ASIC[81] ls_en_asic_buf4 vdd vss net275[9] /
+ physpineu_ND2D2BWP7T30P140
Xi52<8> TSV_TM_88_1_ASIC[80] ls_en_asic_buf4 vdd vss net275[8] /
+ physpineu_ND2D2BWP7T30P140
Xi52<7> TSV_TM_88_1_ASIC[79] ls_en_asic_buf4 vdd vss net275[7] /
+ physpineu_ND2D2BWP7T30P140
Xi52<6> TSV_TM_88_1_ASIC[78] ls_en_asic_buf4 vdd vss net275[6] /
+ physpineu_ND2D2BWP7T30P140
Xi52<5> TSV_TM_88_1_ASIC[77] ls_en_asic_buf4 vdd vss net275[5] /
+ physpineu_ND2D2BWP7T30P140
Xi52<4> TSV_TM_88_1_ASIC[76] ls_en_asic_buf4 vdd vss net275[4] /
+ physpineu_ND2D2BWP7T30P140
Xi52<3> TSV_TM_88_1_ASIC[75] ls_en_asic_buf4 vdd vss net275[3] /
+ physpineu_ND2D2BWP7T30P140
Xi52<2> TSV_TM_88_1_ASIC[74] ls_en_asic_buf4 vdd vss net275[2] /
+ physpineu_ND2D2BWP7T30P140
Xi52<1> TSV_TM_88_1_ASIC[73] ls_en_asic_buf4 vdd vss net275[1] /
+ physpineu_ND2D2BWP7T30P140
Xi52<0> TSV_TM_88_1_ASIC[72] ls_en_asic_buf4 vdd vss net275[0] /
+ physpineu_ND2D2BWP7T30P140
Xi141 TM_REDUMP_ASIC ls_en_asic_buf12 vdd vss net263 / physpineu_ND2D2BWP7T30P140
Xi139 STOPWATCH_PERIOD_ASIC ls_en_asic_buf12 vdd vss net265 / physpineu_ND2D2BWP7T30P140
Xi146 SPINE_RESET_N_ASIC ls_en_asic_buf12 vdd vss net259 / physpineu_ND2D2BWP7T30P140
Xi73<17> TSV_TM_332_205_ASIC[125] ls_en_asic_buf11 vdd vss net268[17] /
+ physpineu_ND2D2BWP7T30P140
Xi73<16> TSV_TM_332_205_ASIC[124] ls_en_asic_buf11 vdd vss net268[16] /
+ physpineu_ND2D2BWP7T30P140
Xi73<15> TSV_TM_332_205_ASIC[123] ls_en_asic_buf11 vdd vss net268[15] /
+ physpineu_ND2D2BWP7T30P140
Xi73<14> TSV_TM_332_205_ASIC[122] ls_en_asic_buf11 vdd vss net268[14] /
+ physpineu_ND2D2BWP7T30P140
Xi73<13> TSV_TM_332_205_ASIC[121] ls_en_asic_buf11 vdd vss net268[13] /
+ physpineu_ND2D2BWP7T30P140
Xi73<12> TSV_TM_332_205_ASIC[120] ls_en_asic_buf11 vdd vss net268[12] /
+ physpineu_ND2D2BWP7T30P140
Xi73<11> TSV_TM_332_205_ASIC[119] ls_en_asic_buf11 vdd vss net268[11] /
+ physpineu_ND2D2BWP7T30P140
Xi73<10> TSV_TM_332_205_ASIC[118] ls_en_asic_buf11 vdd vss net268[10] /
+ physpineu_ND2D2BWP7T30P140
Xi73<9> TSV_TM_332_205_ASIC[117] ls_en_asic_buf11 vdd vss net268[9] /
+ physpineu_ND2D2BWP7T30P140
Xi73<8> TSV_TM_332_205_ASIC[116] ls_en_asic_buf11 vdd vss net268[8] /
+ physpineu_ND2D2BWP7T30P140
Xi73<7> TSV_TM_332_205_ASIC[115] ls_en_asic_buf11 vdd vss net268[7] /
+ physpineu_ND2D2BWP7T30P140
Xi73<6> TSV_TM_332_205_ASIC[114] ls_en_asic_buf11 vdd vss net268[6] /
+ physpineu_ND2D2BWP7T30P140
Xi73<5> TSV_TM_332_205_ASIC[113] ls_en_asic_buf11 vdd vss net268[5] /
+ physpineu_ND2D2BWP7T30P140
Xi73<4> TSV_TM_332_205_ASIC[112] ls_en_asic_buf11 vdd vss net268[4] /
+ physpineu_ND2D2BWP7T30P140
Xi73<3> TSV_TM_332_205_ASIC[111] ls_en_asic_buf11 vdd vss net268[3] /
+ physpineu_ND2D2BWP7T30P140
Xi73<2> TSV_TM_332_205_ASIC[110] ls_en_asic_buf11 vdd vss net268[2] /
+ physpineu_ND2D2BWP7T30P140
Xi73<1> TSV_TM_332_205_ASIC[109] ls_en_asic_buf11 vdd vss net268[1] /
+ physpineu_ND2D2BWP7T30P140
Xi73<0> TSV_TM_332_205_ASIC[108] ls_en_asic_buf11 vdd vss net268[0] /
+ physpineu_ND2D2BWP7T30P140
Xi72<17> TSV_TM_332_205_ASIC[107] ls_en_asic_buf10 vdd vss net269[17] /
+ physpineu_ND2D2BWP7T30P140
Xi72<16> TSV_TM_332_205_ASIC[106] ls_en_asic_buf10 vdd vss net269[16] /
+ physpineu_ND2D2BWP7T30P140
Xi72<15> TSV_TM_332_205_ASIC[105] ls_en_asic_buf10 vdd vss net269[15] /
+ physpineu_ND2D2BWP7T30P140
Xi72<14> TSV_TM_332_205_ASIC[104] ls_en_asic_buf10 vdd vss net269[14] /
+ physpineu_ND2D2BWP7T30P140
Xi72<13> TSV_TM_332_205_ASIC[103] ls_en_asic_buf10 vdd vss net269[13] /
+ physpineu_ND2D2BWP7T30P140
Xi72<12> TSV_TM_332_205_ASIC[102] ls_en_asic_buf10 vdd vss net269[12] /
+ physpineu_ND2D2BWP7T30P140
Xi72<11> TSV_TM_332_205_ASIC[101] ls_en_asic_buf10 vdd vss net269[11] /
+ physpineu_ND2D2BWP7T30P140
Xi72<10> TSV_TM_332_205_ASIC[100] ls_en_asic_buf10 vdd vss net269[10] /
+ physpineu_ND2D2BWP7T30P140
Xi72<9> TSV_TM_332_205_ASIC[99] ls_en_asic_buf10 vdd vss net269[9] /
+ physpineu_ND2D2BWP7T30P140
Xi72<8> TSV_TM_332_205_ASIC[98] ls_en_asic_buf10 vdd vss net269[8] /
+ physpineu_ND2D2BWP7T30P140
Xi72<7> TSV_TM_332_205_ASIC[97] ls_en_asic_buf10 vdd vss net269[7] /
+ physpineu_ND2D2BWP7T30P140
Xi72<6> TSV_TM_332_205_ASIC[96] ls_en_asic_buf10 vdd vss net269[6] /
+ physpineu_ND2D2BWP7T30P140
Xi72<5> TSV_TM_332_205_ASIC[95] ls_en_asic_buf10 vdd vss net269[5] /
+ physpineu_ND2D2BWP7T30P140
Xi72<4> TSV_TM_332_205_ASIC[94] ls_en_asic_buf10 vdd vss net269[4] /
+ physpineu_ND2D2BWP7T30P140
Xi72<3> TSV_TM_332_205_ASIC[93] ls_en_asic_buf10 vdd vss net269[3] /
+ physpineu_ND2D2BWP7T30P140
Xi72<2> TSV_TM_332_205_ASIC[92] ls_en_asic_buf10 vdd vss net269[2] /
+ physpineu_ND2D2BWP7T30P140
Xi72<1> TSV_TM_332_205_ASIC[91] ls_en_asic_buf10 vdd vss net269[1] /
+ physpineu_ND2D2BWP7T30P140
Xi72<0> TSV_TM_332_205_ASIC[90] ls_en_asic_buf10 vdd vss net269[0] /
+ physpineu_ND2D2BWP7T30P140
Xi74<1> TSV_TM_332_205_ASIC[127] ls_en_asic_buf15 vdd vss net267[1] /
+ physpineu_ND2D2BWP7T30P140
Xi74<0> TSV_TM_332_205_ASIC[126] ls_en_asic_buf15 vdd vss net267[0] /
+ physpineu_ND2D2BWP7T30P140
Xi57<17> TSV_TM_332_205_ASIC[89] ls_en_asic_buf9 vdd vss net273[17] /
+ physpineu_ND2D2BWP7T30P140
Xi57<16> TSV_TM_332_205_ASIC[88] ls_en_asic_buf9 vdd vss net273[16] /
+ physpineu_ND2D2BWP7T30P140
Xi57<15> TSV_TM_332_205_ASIC[87] ls_en_asic_buf9 vdd vss net273[15] /
+ physpineu_ND2D2BWP7T30P140
Xi57<14> TSV_TM_332_205_ASIC[86] ls_en_asic_buf9 vdd vss net273[14] /
+ physpineu_ND2D2BWP7T30P140
Xi57<13> TSV_TM_332_205_ASIC[85] ls_en_asic_buf9 vdd vss net273[13] /
+ physpineu_ND2D2BWP7T30P140
Xi57<12> TSV_TM_332_205_ASIC[84] ls_en_asic_buf9 vdd vss net273[12] /
+ physpineu_ND2D2BWP7T30P140
Xi57<11> TSV_TM_332_205_ASIC[83] ls_en_asic_buf9 vdd vss net273[11] /
+ physpineu_ND2D2BWP7T30P140
Xi57<10> TSV_TM_332_205_ASIC[82] ls_en_asic_buf9 vdd vss net273[10] /
+ physpineu_ND2D2BWP7T30P140
Xi57<9> TSV_TM_332_205_ASIC[81] ls_en_asic_buf9 vdd vss net273[9] /
+ physpineu_ND2D2BWP7T30P140
Xi57<8> TSV_TM_332_205_ASIC[80] ls_en_asic_buf9 vdd vss net273[8] /
+ physpineu_ND2D2BWP7T30P140
Xi57<7> TSV_TM_332_205_ASIC[79] ls_en_asic_buf9 vdd vss net273[7] /
+ physpineu_ND2D2BWP7T30P140
Xi57<6> TSV_TM_332_205_ASIC[78] ls_en_asic_buf9 vdd vss net273[6] /
+ physpineu_ND2D2BWP7T30P140
Xi57<5> TSV_TM_332_205_ASIC[77] ls_en_asic_buf9 vdd vss net273[5] /
+ physpineu_ND2D2BWP7T30P140
Xi57<4> TSV_TM_332_205_ASIC[76] ls_en_asic_buf9 vdd vss net273[4] /
+ physpineu_ND2D2BWP7T30P140
Xi57<3> TSV_TM_332_205_ASIC[75] ls_en_asic_buf9 vdd vss net273[3] /
+ physpineu_ND2D2BWP7T30P140
Xi57<2> TSV_TM_332_205_ASIC[74] ls_en_asic_buf9 vdd vss net273[2] /
+ physpineu_ND2D2BWP7T30P140
Xi57<1> TSV_TM_332_205_ASIC[73] ls_en_asic_buf9 vdd vss net273[1] /
+ physpineu_ND2D2BWP7T30P140
Xi57<0> TSV_TM_332_205_ASIC[72] ls_en_asic_buf9 vdd vss net273[0] /
+ physpineu_ND2D2BWP7T30P140
Xi56<17> TSV_TM_332_205_ASIC[71] ls_en_asic_buf8 vdd vss net270[17] /
+ physpineu_ND2D2BWP7T30P140
Xi56<16> TSV_TM_332_205_ASIC[70] ls_en_asic_buf8 vdd vss net270[16] /
+ physpineu_ND2D2BWP7T30P140
Xi56<15> TSV_TM_332_205_ASIC[69] ls_en_asic_buf8 vdd vss net270[15] /
+ physpineu_ND2D2BWP7T30P140
Xi56<14> TSV_TM_332_205_ASIC[68] ls_en_asic_buf8 vdd vss net270[14] /
+ physpineu_ND2D2BWP7T30P140
Xi56<13> TSV_TM_332_205_ASIC[67] ls_en_asic_buf8 vdd vss net270[13] /
+ physpineu_ND2D2BWP7T30P140
Xi56<12> TSV_TM_332_205_ASIC[66] ls_en_asic_buf8 vdd vss net270[12] /
+ physpineu_ND2D2BWP7T30P140
Xi56<11> TSV_TM_332_205_ASIC[65] ls_en_asic_buf8 vdd vss net270[11] /
+ physpineu_ND2D2BWP7T30P140
Xi56<10> TSV_TM_332_205_ASIC[64] ls_en_asic_buf8 vdd vss net270[10] /
+ physpineu_ND2D2BWP7T30P140
Xi56<9> TSV_TM_332_205_ASIC[63] ls_en_asic_buf8 vdd vss net270[9] /
+ physpineu_ND2D2BWP7T30P140
Xi56<8> TSV_TM_332_205_ASIC[62] ls_en_asic_buf8 vdd vss net270[8] /
+ physpineu_ND2D2BWP7T30P140
Xi56<7> TSV_TM_332_205_ASIC[61] ls_en_asic_buf8 vdd vss net270[7] /
+ physpineu_ND2D2BWP7T30P140
Xi56<6> TSV_TM_332_205_ASIC[60] ls_en_asic_buf8 vdd vss net270[6] /
+ physpineu_ND2D2BWP7T30P140
Xi56<5> TSV_TM_332_205_ASIC[59] ls_en_asic_buf8 vdd vss net270[5] /
+ physpineu_ND2D2BWP7T30P140
Xi56<4> TSV_TM_332_205_ASIC[58] ls_en_asic_buf8 vdd vss net270[4] /
+ physpineu_ND2D2BWP7T30P140
Xi56<3> TSV_TM_332_205_ASIC[57] ls_en_asic_buf8 vdd vss net270[3] /
+ physpineu_ND2D2BWP7T30P140
Xi56<2> TSV_TM_332_205_ASIC[56] ls_en_asic_buf8 vdd vss net270[2] /
+ physpineu_ND2D2BWP7T30P140
Xi56<1> TSV_TM_332_205_ASIC[55] ls_en_asic_buf8 vdd vss net270[1] /
+ physpineu_ND2D2BWP7T30P140
Xi56<0> TSV_TM_332_205_ASIC[54] ls_en_asic_buf8 vdd vss net270[0] /
+ physpineu_ND2D2BWP7T30P140
Xi55<17> TSV_TM_332_205_ASIC[53] ls_en_asic_buf7 vdd vss net271[17] /
+ physpineu_ND2D2BWP7T30P140
Xi55<16> TSV_TM_332_205_ASIC[52] ls_en_asic_buf7 vdd vss net271[16] /
+ physpineu_ND2D2BWP7T30P140
Xi55<15> TSV_TM_332_205_ASIC[51] ls_en_asic_buf7 vdd vss net271[15] /
+ physpineu_ND2D2BWP7T30P140
Xi55<14> TSV_TM_332_205_ASIC[50] ls_en_asic_buf7 vdd vss net271[14] /
+ physpineu_ND2D2BWP7T30P140
Xi55<13> TSV_TM_332_205_ASIC[49] ls_en_asic_buf7 vdd vss net271[13] /
+ physpineu_ND2D2BWP7T30P140
Xi55<12> TSV_TM_332_205_ASIC[48] ls_en_asic_buf7 vdd vss net271[12] /
+ physpineu_ND2D2BWP7T30P140
Xi55<11> TSV_TM_332_205_ASIC[47] ls_en_asic_buf7 vdd vss net271[11] /
+ physpineu_ND2D2BWP7T30P140
Xi55<10> TSV_TM_332_205_ASIC[46] ls_en_asic_buf7 vdd vss net271[10] /
+ physpineu_ND2D2BWP7T30P140
Xi55<9> TSV_TM_332_205_ASIC[45] ls_en_asic_buf7 vdd vss net271[9] /
+ physpineu_ND2D2BWP7T30P140
Xi55<8> TSV_TM_332_205_ASIC[44] ls_en_asic_buf7 vdd vss net271[8] /
+ physpineu_ND2D2BWP7T30P140
Xi55<7> TSV_TM_332_205_ASIC[43] ls_en_asic_buf7 vdd vss net271[7] /
+ physpineu_ND2D2BWP7T30P140
Xi55<6> TSV_TM_332_205_ASIC[42] ls_en_asic_buf7 vdd vss net271[6] /
+ physpineu_ND2D2BWP7T30P140
Xi55<5> TSV_TM_332_205_ASIC[41] ls_en_asic_buf7 vdd vss net271[5] /
+ physpineu_ND2D2BWP7T30P140
Xi55<4> TSV_TM_332_205_ASIC[40] ls_en_asic_buf7 vdd vss net271[4] /
+ physpineu_ND2D2BWP7T30P140
Xi55<3> TSV_TM_332_205_ASIC[39] ls_en_asic_buf7 vdd vss net271[3] /
+ physpineu_ND2D2BWP7T30P140
Xi55<2> TSV_TM_332_205_ASIC[38] ls_en_asic_buf7 vdd vss net271[2] /
+ physpineu_ND2D2BWP7T30P140
Xi55<1> TSV_TM_332_205_ASIC[37] ls_en_asic_buf7 vdd vss net271[1] /
+ physpineu_ND2D2BWP7T30P140
Xi55<0> TSV_TM_332_205_ASIC[36] ls_en_asic_buf7 vdd vss net271[0] /
+ physpineu_ND2D2BWP7T30P140
Xi54<17> TSV_TM_332_205_ASIC[35] ls_en_asic_buf6 vdd vss net272[17] /
+ physpineu_ND2D2BWP7T30P140
Xi54<16> TSV_TM_332_205_ASIC[34] ls_en_asic_buf6 vdd vss net272[16] /
+ physpineu_ND2D2BWP7T30P140
Xi54<15> TSV_TM_332_205_ASIC[33] ls_en_asic_buf6 vdd vss net272[15] /
+ physpineu_ND2D2BWP7T30P140
Xi54<14> TSV_TM_332_205_ASIC[32] ls_en_asic_buf6 vdd vss net272[14] /
+ physpineu_ND2D2BWP7T30P140
Xi54<13> TSV_TM_332_205_ASIC[31] ls_en_asic_buf6 vdd vss net272[13] /
+ physpineu_ND2D2BWP7T30P140
Xi54<12> TSV_TM_332_205_ASIC[30] ls_en_asic_buf6 vdd vss net272[12] /
+ physpineu_ND2D2BWP7T30P140
Xi54<11> TSV_TM_332_205_ASIC[29] ls_en_asic_buf6 vdd vss net272[11] /
+ physpineu_ND2D2BWP7T30P140
Xi54<10> TSV_TM_332_205_ASIC[28] ls_en_asic_buf6 vdd vss net272[10] /
+ physpineu_ND2D2BWP7T30P140
Xi54<9> TSV_TM_332_205_ASIC[27] ls_en_asic_buf6 vdd vss net272[9] /
+ physpineu_ND2D2BWP7T30P140
Xi54<8> TSV_TM_332_205_ASIC[26] ls_en_asic_buf6 vdd vss net272[8] /
+ physpineu_ND2D2BWP7T30P140
Xi54<7> TSV_TM_332_205_ASIC[25] ls_en_asic_buf6 vdd vss net272[7] /
+ physpineu_ND2D2BWP7T30P140
Xi54<6> TSV_TM_332_205_ASIC[24] ls_en_asic_buf6 vdd vss net272[6] /
+ physpineu_ND2D2BWP7T30P140
Xi54<5> TSV_TM_332_205_ASIC[23] ls_en_asic_buf6 vdd vss net272[5] /
+ physpineu_ND2D2BWP7T30P140
Xi54<4> TSV_TM_332_205_ASIC[22] ls_en_asic_buf6 vdd vss net272[4] /
+ physpineu_ND2D2BWP7T30P140
Xi54<3> TSV_TM_332_205_ASIC[21] ls_en_asic_buf6 vdd vss net272[3] /
+ physpineu_ND2D2BWP7T30P140
Xi54<2> TSV_TM_332_205_ASIC[20] ls_en_asic_buf6 vdd vss net272[2] /
+ physpineu_ND2D2BWP7T30P140
Xi54<1> TSV_TM_332_205_ASIC[19] ls_en_asic_buf6 vdd vss net272[1] /
+ physpineu_ND2D2BWP7T30P140
Xi54<0> TSV_TM_332_205_ASIC[18] ls_en_asic_buf6 vdd vss net272[0] /
+ physpineu_ND2D2BWP7T30P140
Xi53<17> TSV_TM_332_205_ASIC[17] ls_en_asic_buf5 vdd vss net274[17] /
+ physpineu_ND2D2BWP7T30P140
Xi53<16> TSV_TM_332_205_ASIC[16] ls_en_asic_buf5 vdd vss net274[16] /
+ physpineu_ND2D2BWP7T30P140
Xi53<15> TSV_TM_332_205_ASIC[15] ls_en_asic_buf5 vdd vss net274[15] /
+ physpineu_ND2D2BWP7T30P140
Xi53<14> TSV_TM_332_205_ASIC[14] ls_en_asic_buf5 vdd vss net274[14] /
+ physpineu_ND2D2BWP7T30P140
Xi53<13> TSV_TM_332_205_ASIC[13] ls_en_asic_buf5 vdd vss net274[13] /
+ physpineu_ND2D2BWP7T30P140
Xi53<12> TSV_TM_332_205_ASIC[12] ls_en_asic_buf5 vdd vss net274[12] /
+ physpineu_ND2D2BWP7T30P140
Xi53<11> TSV_TM_332_205_ASIC[11] ls_en_asic_buf5 vdd vss net274[11] /
+ physpineu_ND2D2BWP7T30P140
Xi53<10> TSV_TM_332_205_ASIC[10] ls_en_asic_buf5 vdd vss net274[10] /
+ physpineu_ND2D2BWP7T30P140
Xi53<9> TSV_TM_332_205_ASIC[9] ls_en_asic_buf5 vdd vss net274[9] /
+ physpineu_ND2D2BWP7T30P140
Xi53<8> TSV_TM_332_205_ASIC[8] ls_en_asic_buf5 vdd vss net274[8] /
+ physpineu_ND2D2BWP7T30P140
Xi53<7> TSV_TM_332_205_ASIC[7] ls_en_asic_buf5 vdd vss net274[7] /
+ physpineu_ND2D2BWP7T30P140
Xi53<6> TSV_TM_332_205_ASIC[6] ls_en_asic_buf5 vdd vss net274[6] /
+ physpineu_ND2D2BWP7T30P140
Xi53<5> TSV_TM_332_205_ASIC[5] ls_en_asic_buf5 vdd vss net274[5] /
+ physpineu_ND2D2BWP7T30P140
Xi53<4> TSV_TM_332_205_ASIC[4] ls_en_asic_buf5 vdd vss net274[4] /
+ physpineu_ND2D2BWP7T30P140
Xi53<3> TSV_TM_332_205_ASIC[3] ls_en_asic_buf5 vdd vss net274[3] /
+ physpineu_ND2D2BWP7T30P140
Xi53<2> TSV_TM_332_205_ASIC[2] ls_en_asic_buf5 vdd vss net274[2] /
+ physpineu_ND2D2BWP7T30P140
Xi53<1> TSV_TM_332_205_ASIC[1] ls_en_asic_buf5 vdd vss net274[1] /
+ physpineu_ND2D2BWP7T30P140
Xi53<0> TSV_TM_332_205_ASIC[0] ls_en_asic_buf5 vdd vss net274[0] /
+ physpineu_ND2D2BWP7T30P140
Xi50<17> TSV_TM_88_1_ASIC[71] ls_en_asic_buf3 vdd vss net276[17] /
+ physpineu_ND2D2BWP7T30P140
Xi50<16> TSV_TM_88_1_ASIC[70] ls_en_asic_buf3 vdd vss net276[16] /
+ physpineu_ND2D2BWP7T30P140
Xi50<15> TSV_TM_88_1_ASIC[69] ls_en_asic_buf3 vdd vss net276[15] /
+ physpineu_ND2D2BWP7T30P140
Xi50<14> TSV_TM_88_1_ASIC[68] ls_en_asic_buf3 vdd vss net276[14] /
+ physpineu_ND2D2BWP7T30P140
Xi50<13> TSV_TM_88_1_ASIC[67] ls_en_asic_buf3 vdd vss net276[13] /
+ physpineu_ND2D2BWP7T30P140
Xi50<12> TSV_TM_88_1_ASIC[66] ls_en_asic_buf3 vdd vss net276[12] /
+ physpineu_ND2D2BWP7T30P140
Xi50<11> TSV_TM_88_1_ASIC[65] ls_en_asic_buf3 vdd vss net276[11] /
+ physpineu_ND2D2BWP7T30P140
Xi50<10> TSV_TM_88_1_ASIC[64] ls_en_asic_buf3 vdd vss net276[10] /
+ physpineu_ND2D2BWP7T30P140
Xi50<9> TSV_TM_88_1_ASIC[63] ls_en_asic_buf3 vdd vss net276[9] /
+ physpineu_ND2D2BWP7T30P140
Xi50<8> TSV_TM_88_1_ASIC[62] ls_en_asic_buf3 vdd vss net276[8] /
+ physpineu_ND2D2BWP7T30P140
Xi50<7> TSV_TM_88_1_ASIC[61] ls_en_asic_buf3 vdd vss net276[7] /
+ physpineu_ND2D2BWP7T30P140
Xi50<6> TSV_TM_88_1_ASIC[60] ls_en_asic_buf3 vdd vss net276[6] /
+ physpineu_ND2D2BWP7T30P140
Xi50<5> TSV_TM_88_1_ASIC[59] ls_en_asic_buf3 vdd vss net276[5] /
+ physpineu_ND2D2BWP7T30P140
Xi50<4> TSV_TM_88_1_ASIC[58] ls_en_asic_buf3 vdd vss net276[4] /
+ physpineu_ND2D2BWP7T30P140
Xi50<3> TSV_TM_88_1_ASIC[57] ls_en_asic_buf3 vdd vss net276[3] /
+ physpineu_ND2D2BWP7T30P140
Xi50<2> TSV_TM_88_1_ASIC[56] ls_en_asic_buf3 vdd vss net276[2] /
+ physpineu_ND2D2BWP7T30P140
Xi50<1> TSV_TM_88_1_ASIC[55] ls_en_asic_buf3 vdd vss net276[1] /
+ physpineu_ND2D2BWP7T30P140
Xi50<0> TSV_TM_88_1_ASIC[54] ls_en_asic_buf3 vdd vss net276[0] /
+ physpineu_ND2D2BWP7T30P140
Xi49<17> TSV_TM_88_1_ASIC[53] ls_en_asic_buf2 vdd vss net277[17] /
+ physpineu_ND2D2BWP7T30P140
Xi49<16> TSV_TM_88_1_ASIC[52] ls_en_asic_buf2 vdd vss net277[16] /
+ physpineu_ND2D2BWP7T30P140
Xi49<15> TSV_TM_88_1_ASIC[51] ls_en_asic_buf2 vdd vss net277[15] /
+ physpineu_ND2D2BWP7T30P140
Xi49<14> TSV_TM_88_1_ASIC[50] ls_en_asic_buf2 vdd vss net277[14] /
+ physpineu_ND2D2BWP7T30P140
Xi49<13> TSV_TM_88_1_ASIC[49] ls_en_asic_buf2 vdd vss net277[13] /
+ physpineu_ND2D2BWP7T30P140
Xi49<12> TSV_TM_88_1_ASIC[48] ls_en_asic_buf2 vdd vss net277[12] /
+ physpineu_ND2D2BWP7T30P140
Xi49<11> TSV_TM_88_1_ASIC[47] ls_en_asic_buf2 vdd vss net277[11] /
+ physpineu_ND2D2BWP7T30P140
Xi49<10> TSV_TM_88_1_ASIC[46] ls_en_asic_buf2 vdd vss net277[10] /
+ physpineu_ND2D2BWP7T30P140
Xi49<9> TSV_TM_88_1_ASIC[45] ls_en_asic_buf2 vdd vss net277[9] /
+ physpineu_ND2D2BWP7T30P140
Xi49<8> TSV_TM_88_1_ASIC[44] ls_en_asic_buf2 vdd vss net277[8] /
+ physpineu_ND2D2BWP7T30P140
Xi49<7> TSV_TM_88_1_ASIC[43] ls_en_asic_buf2 vdd vss net277[7] /
+ physpineu_ND2D2BWP7T30P140
Xi49<6> TSV_TM_88_1_ASIC[42] ls_en_asic_buf2 vdd vss net277[6] /
+ physpineu_ND2D2BWP7T30P140
Xi49<5> TSV_TM_88_1_ASIC[41] ls_en_asic_buf2 vdd vss net277[5] /
+ physpineu_ND2D2BWP7T30P140
Xi49<4> TSV_TM_88_1_ASIC[40] ls_en_asic_buf2 vdd vss net277[4] /
+ physpineu_ND2D2BWP7T30P140
Xi49<3> TSV_TM_88_1_ASIC[39] ls_en_asic_buf2 vdd vss net277[3] /
+ physpineu_ND2D2BWP7T30P140
Xi49<2> TSV_TM_88_1_ASIC[38] ls_en_asic_buf2 vdd vss net277[2] /
+ physpineu_ND2D2BWP7T30P140
Xi49<1> TSV_TM_88_1_ASIC[37] ls_en_asic_buf2 vdd vss net277[1] /
+ physpineu_ND2D2BWP7T30P140
Xi49<0> TSV_TM_88_1_ASIC[36] ls_en_asic_buf2 vdd vss net277[0] /
+ physpineu_ND2D2BWP7T30P140
Xi47<17> TSV_TM_88_1_ASIC[35] ls_en_asic_buf1 vdd vss net278[17] /
+ physpineu_ND2D2BWP7T30P140
Xi47<16> TSV_TM_88_1_ASIC[34] ls_en_asic_buf1 vdd vss net278[16] /
+ physpineu_ND2D2BWP7T30P140
Xi47<15> TSV_TM_88_1_ASIC[33] ls_en_asic_buf1 vdd vss net278[15] /
+ physpineu_ND2D2BWP7T30P140
Xi47<14> TSV_TM_88_1_ASIC[32] ls_en_asic_buf1 vdd vss net278[14] /
+ physpineu_ND2D2BWP7T30P140
Xi47<13> TSV_TM_88_1_ASIC[31] ls_en_asic_buf1 vdd vss net278[13] /
+ physpineu_ND2D2BWP7T30P140
Xi47<12> TSV_TM_88_1_ASIC[30] ls_en_asic_buf1 vdd vss net278[12] /
+ physpineu_ND2D2BWP7T30P140
Xi47<11> TSV_TM_88_1_ASIC[29] ls_en_asic_buf1 vdd vss net278[11] /
+ physpineu_ND2D2BWP7T30P140
Xi47<10> TSV_TM_88_1_ASIC[28] ls_en_asic_buf1 vdd vss net278[10] /
+ physpineu_ND2D2BWP7T30P140
Xi47<9> TSV_TM_88_1_ASIC[27] ls_en_asic_buf1 vdd vss net278[9] /
+ physpineu_ND2D2BWP7T30P140
Xi47<8> TSV_TM_88_1_ASIC[26] ls_en_asic_buf1 vdd vss net278[8] /
+ physpineu_ND2D2BWP7T30P140
Xi47<7> TSV_TM_88_1_ASIC[25] ls_en_asic_buf1 vdd vss net278[7] /
+ physpineu_ND2D2BWP7T30P140
Xi47<6> TSV_TM_88_1_ASIC[24] ls_en_asic_buf1 vdd vss net278[6] /
+ physpineu_ND2D2BWP7T30P140
Xi47<5> TSV_TM_88_1_ASIC[23] ls_en_asic_buf1 vdd vss net278[5] /
+ physpineu_ND2D2BWP7T30P140
Xi47<4> TSV_TM_88_1_ASIC[22] ls_en_asic_buf1 vdd vss net278[4] /
+ physpineu_ND2D2BWP7T30P140
Xi47<3> TSV_TM_88_1_ASIC[21] ls_en_asic_buf1 vdd vss net278[3] /
+ physpineu_ND2D2BWP7T30P140
Xi47<2> TSV_TM_88_1_ASIC[20] ls_en_asic_buf1 vdd vss net278[2] /
+ physpineu_ND2D2BWP7T30P140
Xi47<1> TSV_TM_88_1_ASIC[19] ls_en_asic_buf1 vdd vss net278[1] /
+ physpineu_ND2D2BWP7T30P140
Xi47<0> TSV_TM_88_1_ASIC[18] ls_en_asic_buf1 vdd vss net278[0] /
+ physpineu_ND2D2BWP7T30P140
Xi0<17> TSV_TM_88_1_ASIC[17] ls_en_asic_buf0 vdd vss net279[17] /
+ physpineu_ND2D2BWP7T30P140
Xi0<16> TSV_TM_88_1_ASIC[16] ls_en_asic_buf0 vdd vss net279[16] /
+ physpineu_ND2D2BWP7T30P140
Xi0<15> TSV_TM_88_1_ASIC[15] ls_en_asic_buf0 vdd vss net279[15] /
+ physpineu_ND2D2BWP7T30P140
Xi0<14> TSV_TM_88_1_ASIC[14] ls_en_asic_buf0 vdd vss net279[14] /
+ physpineu_ND2D2BWP7T30P140
Xi0<13> TSV_TM_88_1_ASIC[13] ls_en_asic_buf0 vdd vss net279[13] /
+ physpineu_ND2D2BWP7T30P140
Xi0<12> TSV_TM_88_1_ASIC[12] ls_en_asic_buf0 vdd vss net279[12] /
+ physpineu_ND2D2BWP7T30P140
Xi0<11> TSV_TM_88_1_ASIC[11] ls_en_asic_buf0 vdd vss net279[11] /
+ physpineu_ND2D2BWP7T30P140
Xi0<10> TSV_TM_88_1_ASIC[10] ls_en_asic_buf0 vdd vss net279[10] /
+ physpineu_ND2D2BWP7T30P140
Xi0<9> TSV_TM_88_1_ASIC[9] ls_en_asic_buf0 vdd vss net279[9] / physpineu_ND2D2BWP7T30P140
Xi0<8> TSV_TM_88_1_ASIC[8] ls_en_asic_buf0 vdd vss net279[8] / physpineu_ND2D2BWP7T30P140
Xi0<7> TSV_TM_88_1_ASIC[7] ls_en_asic_buf0 vdd vss net279[7] / physpineu_ND2D2BWP7T30P140
Xi0<6> TSV_TM_88_1_ASIC[6] ls_en_asic_buf0 vdd vss net279[6] / physpineu_ND2D2BWP7T30P140
Xi0<5> TSV_TM_88_1_ASIC[5] ls_en_asic_buf0 vdd vss net279[5] / physpineu_ND2D2BWP7T30P140
Xi0<4> TSV_TM_88_1_ASIC[4] ls_en_asic_buf0 vdd vss net279[4] / physpineu_ND2D2BWP7T30P140
Xi0<3> TSV_TM_88_1_ASIC[3] ls_en_asic_buf0 vdd vss net279[3] / physpineu_ND2D2BWP7T30P140
Xi0<2> TSV_TM_88_1_ASIC[2] ls_en_asic_buf0 vdd vss net279[2] / physpineu_ND2D2BWP7T30P140
Xi0<1> TSV_TM_88_1_ASIC[1] ls_en_asic_buf0 vdd vss net279[1] / physpineu_ND2D2BWP7T30P140
Xi0<0> TSV_TM_88_1_ASIC[0] ls_en_asic_buf0 vdd vss net279[0] / physpineu_ND2D2BWP7T30P140
Xi314 vdd vss net260 / physpineu_TIEHBWP7T30P140
Xi315 vdd vss net258 / physpineu_TIEHBWP7T30P140
Xi317 vdd vss net627 / physpineu_TIEHBWP7T30P140
Xi319<1> vdd vss net6[1] / physpineu_TIEHBWP7T30P140
Xi319<0> vdd vss net6[0] / physpineu_TIEHBWP7T30P140
Xi318 vdd vss net702 / physpineu_TIEHBWP7T30P140
Xi312 vdd vss net558 / physpineu_TIEHBWP7T30P140
Xi310<1> vdd vss net5[1] / physpineu_TIEHBWP7T30P140
Xi310<0> vdd vss net5[0] / physpineu_TIEHBWP7T30P140
Xi311 vdd vss net555 / physpineu_TIEHBWP7T30P140
Xi316<1> vdd vss net1[1] / physpineu_TIEHBWP7T30P140
Xi316<0> vdd vss net1[0] / physpineu_TIEHBWP7T30P140
Xi313<1> vdd vss net4[1] / physpineu_TIEHBWP7T30P140
Xi313<0> vdd vss net4[0] / physpineu_TIEHBWP7T30P140
Xi309 vdd vss net573 / physpineu_TIEHBWP7T30P140
Xi332 vdd vss net2 / physpineu_TIEHBWP7T30P140
MM2<0> vss_array vdd_array vss_array vss_array nch_18ud12_mac l=800n w=800n
+ m=2 nf=1
MM2<1> vss_array vdd_array vss_array vss_array nch_18ud12_mac l=800n w=800n
+ m=2 nf=1
MM2<2> vss_array vdd_array vss_array vss_array nch_18ud12_mac l=800n w=800n
+ m=2 nf=1
MM2<3> vss_array vdd_array vss_array vss_array nch_18ud12_mac l=800n w=800n
+ m=2 nf=1
MM2<4> vss_array vdd_array vss_array vss_array nch_18ud12_mac l=800n w=800n
+ m=2 nf=1
MM2<5> vss_array vdd_array vss_array vss_array nch_18ud12_mac l=800n w=800n
+ m=2 nf=1
MM2<6> vss_array vdd_array vss_array vss_array nch_18ud12_mac l=800n w=800n
+ m=2 nf=1
MM2<7> vss_array vdd_array vss_array vss_array nch_18ud12_mac l=800n w=800n
+ m=2 nf=1
MM2<8> vss_array vdd_array vss_array vss_array nch_18ud12_mac l=800n w=800n
+ m=2 nf=1
MM2<9> vss_array vdd_array vss_array vss_array nch_18ud12_mac l=800n w=800n
+ m=2 nf=1
MM2<10> vss_array vdd_array vss_array vss_array nch_18ud12_mac l=800n w=800n
+ m=2 nf=1
MM2<11> vss_array vdd_array vss_array vss_array nch_18ud12_mac l=800n w=800n
+ m=2 nf=1
MM2<12> vss_array vdd_array vss_array vss_array nch_18ud12_mac l=800n w=800n
+ m=2 nf=1
MM2<13> vss_array vdd_array vss_array vss_array nch_18ud12_mac l=800n w=800n
+ m=2 nf=1
MM2<14> vss_array vdd_array vss_array vss_array nch_18ud12_mac l=800n w=800n
+ m=2 nf=1
MM2<15> vss_array vdd_array vss_array vss_array nch_18ud12_mac l=800n w=800n
+ m=2 nf=1
MM2<16> vss_array vdd_array vss_array vss_array nch_18ud12_mac l=800n w=800n
+ m=2 nf=1
MM2<17> vss_array vdd_array vss_array vss_array nch_18ud12_mac l=800n w=800n
+ m=2 nf=1
MM2<18> vss_array vdd_array vss_array vss_array nch_18ud12_mac l=800n w=800n
+ m=2 nf=1
MM2<19> vss_array vdd_array vss_array vss_array nch_18ud12_mac l=800n w=800n
+ m=2 nf=1
MM2<20> vss_array vdd_array vss_array vss_array nch_18ud12_mac l=800n w=800n
+ m=2 nf=1
MM2<21> vss_array vdd_array vss_array vss_array nch_18ud12_mac l=800n w=800n
+ m=2 nf=1
MM2<22> vss_array vdd_array vss_array vss_array nch_18ud12_mac l=800n w=800n
+ m=2 nf=1
MM2<23> vss_array vdd_array vss_array vss_array nch_18ud12_mac l=800n w=800n
+ m=2 nf=1
MM2<24> vss_array vdd_array vss_array vss_array nch_18ud12_mac l=800n w=800n
+ m=2 nf=1
MM2<25> vss_array vdd_array vss_array vss_array nch_18ud12_mac l=800n w=800n
+ m=2 nf=1
MM2<26> vss_array vdd_array vss_array vss_array nch_18ud12_mac l=800n w=800n
+ m=2 nf=1
MM2<27> vss_array vdd_array vss_array vss_array nch_18ud12_mac l=800n w=800n
+ m=2 nf=1
MM2<28> vss_array vdd_array vss_array vss_array nch_18ud12_mac l=800n w=800n
+ m=2 nf=1
MM2<29> vss_array vdd_array vss_array vss_array nch_18ud12_mac l=800n w=800n
+ m=2 nf=1
MM2<30> vss_array vdd_array vss_array vss_array nch_18ud12_mac l=800n w=800n
+ m=2 nf=1
MM2<31> vss_array vdd_array vss_array vss_array nch_18ud12_mac l=800n w=800n
+ m=2 nf=1
MM2<32> vss_array vdd_array vss_array vss_array nch_18ud12_mac l=800n w=800n
+ m=2 nf=1
MM2<33> vss_array vdd_array vss_array vss_array nch_18ud12_mac l=800n w=800n
+ m=2 nf=1
MM2<34> vss_array vdd_array vss_array vss_array nch_18ud12_mac l=800n w=800n
+ m=2 nf=1
MM2<35> vss_array vdd_array vss_array vss_array nch_18ud12_mac l=800n w=800n
+ m=2 nf=1
MM2<36> vss_array vdd_array vss_array vss_array nch_18ud12_mac l=800n w=800n
+ m=2 nf=1
MM2<37> vss_array vdd_array vss_array vss_array nch_18ud12_mac l=800n w=800n
+ m=2 nf=1
MM2<38> vss_array vdd_array vss_array vss_array nch_18ud12_mac l=800n w=800n
+ m=2 nf=1
MM2<39> vss_array vdd_array vss_array vss_array nch_18ud12_mac l=800n w=800n
+ m=2 nf=1
MM2<40> vss_array vdd_array vss_array vss_array nch_18ud12_mac l=800n w=800n
+ m=2 nf=1
MM2<41> vss_array vdd_array vss_array vss_array nch_18ud12_mac l=800n w=800n
+ m=2 nf=1
MM2<42> vss_array vdd_array vss_array vss_array nch_18ud12_mac l=800n w=800n
+ m=2 nf=1
MM2<43> vss_array vdd_array vss_array vss_array nch_18ud12_mac l=800n w=800n
+ m=2 nf=1
MM2<44> vss_array vdd_array vss_array vss_array nch_18ud12_mac l=800n w=800n
+ m=2 nf=1
MM2<45> vss_array vdd_array vss_array vss_array nch_18ud12_mac l=800n w=800n
+ m=2 nf=1
MM2<46> vss_array vdd_array vss_array vss_array nch_18ud12_mac l=800n w=800n
+ m=2 nf=1
MM2<47> vss_array vdd_array vss_array vss_array nch_18ud12_mac l=800n w=800n
+ m=2 nf=1
MM2<48> vss_array vdd_array vss_array vss_array nch_18ud12_mac l=800n w=800n
+ m=2 nf=1
MM2<49> vss_array vdd_array vss_array vss_array nch_18ud12_mac l=800n w=800n
+ m=2 nf=1
MM2<50> vss_array vdd_array vss_array vss_array nch_18ud12_mac l=800n w=800n
+ m=2 nf=1
MM2<51> vss_array vdd_array vss_array vss_array nch_18ud12_mac l=800n w=800n
+ m=2 nf=1
MM2<52> vss_array vdd_array vss_array vss_array nch_18ud12_mac l=800n w=800n
+ m=2 nf=1
MM2<53> vss_array vdd_array vss_array vss_array nch_18ud12_mac l=800n w=800n
+ m=2 nf=1
MM2<54> vss_array vdd_array vss_array vss_array nch_18ud12_mac l=800n w=800n
+ m=2 nf=1
MM2<55> vss_array vdd_array vss_array vss_array nch_18ud12_mac l=800n w=800n
+ m=2 nf=1
MM2<56> vss_array vdd_array vss_array vss_array nch_18ud12_mac l=800n w=800n
+ m=2 nf=1
MM2<57> vss_array vdd_array vss_array vss_array nch_18ud12_mac l=800n w=800n
+ m=2 nf=1
MM2<58> vss_array vdd_array vss_array vss_array nch_18ud12_mac l=800n w=800n
+ m=2 nf=1
MM2<59> vss_array vdd_array vss_array vss_array nch_18ud12_mac l=800n w=800n
+ m=2 nf=1
MM2<60> vss_array vdd_array vss_array vss_array nch_18ud12_mac l=800n w=800n
+ m=2 nf=1
MM2<61> vss_array vdd_array vss_array vss_array nch_18ud12_mac l=800n w=800n
+ m=2 nf=1
MM2<62> vss_array vdd_array vss_array vss_array nch_18ud12_mac l=800n w=800n
+ m=2 nf=1
MM2<63> vss_array vdd_array vss_array vss_array nch_18ud12_mac l=800n w=800n
+ m=2 nf=1
MM2<64> vss_array vdd_array vss_array vss_array nch_18ud12_mac l=800n w=800n
+ m=2 nf=1
MM2<65> vss_array vdd_array vss_array vss_array nch_18ud12_mac l=800n w=800n
+ m=2 nf=1
MM2<66> vss_array vdd_array vss_array vss_array nch_18ud12_mac l=800n w=800n
+ m=2 nf=1
MM2<67> vss_array vdd_array vss_array vss_array nch_18ud12_mac l=800n w=800n
+ m=2 nf=1
MM0<0> vss vdd vss vss nch_18ud12_mac l=800n w=800n m=2 nf=1
MM0<1> vss vdd vss vss nch_18ud12_mac l=800n w=800n m=2 nf=1
MM0<2> vss vdd vss vss nch_18ud12_mac l=800n w=800n m=2 nf=1
MM0<3> vss vdd vss vss nch_18ud12_mac l=800n w=800n m=2 nf=1
MM0<4> vss vdd vss vss nch_18ud12_mac l=800n w=800n m=2 nf=1
MM0<5> vss vdd vss vss nch_18ud12_mac l=800n w=800n m=2 nf=1
MM0<6> vss vdd vss vss nch_18ud12_mac l=800n w=800n m=2 nf=1
MM0<7> vss vdd vss vss nch_18ud12_mac l=800n w=800n m=2 nf=1
MM0<8> vss vdd vss vss nch_18ud12_mac l=800n w=800n m=2 nf=1
MM0<9> vss vdd vss vss nch_18ud12_mac l=800n w=800n m=2 nf=1
MM0<10> vss vdd vss vss nch_18ud12_mac l=800n w=800n m=2 nf=1
MM0<11> vss vdd vss vss nch_18ud12_mac l=800n w=800n m=2 nf=1
MM0<12> vss vdd vss vss nch_18ud12_mac l=800n w=800n m=2 nf=1
MM0<13> vss vdd vss vss nch_18ud12_mac l=800n w=800n m=2 nf=1
MM0<14> vss vdd vss vss nch_18ud12_mac l=800n w=800n m=2 nf=1
MM0<15> vss vdd vss vss nch_18ud12_mac l=800n w=800n m=2 nf=1
MM0<16> vss vdd vss vss nch_18ud12_mac l=800n w=800n m=2 nf=1
MM0<17> vss vdd vss vss nch_18ud12_mac l=800n w=800n m=2 nf=1
MM0<18> vss vdd vss vss nch_18ud12_mac l=800n w=800n m=2 nf=1
MM0<19> vss vdd vss vss nch_18ud12_mac l=800n w=800n m=2 nf=1
MM0<20> vss vdd vss vss nch_18ud12_mac l=800n w=800n m=2 nf=1
MM0<21> vss vdd vss vss nch_18ud12_mac l=800n w=800n m=2 nf=1
MM0<22> vss vdd vss vss nch_18ud12_mac l=800n w=800n m=2 nf=1
MM0<23> vss vdd vss vss nch_18ud12_mac l=800n w=800n m=2 nf=1
MM0<24> vss vdd vss vss nch_18ud12_mac l=800n w=800n m=2 nf=1
MM0<25> vss vdd vss vss nch_18ud12_mac l=800n w=800n m=2 nf=1
MM0<26> vss vdd vss vss nch_18ud12_mac l=800n w=800n m=2 nf=1
MM0<27> vss vdd vss vss nch_18ud12_mac l=800n w=800n m=2 nf=1
MM0<28> vss vdd vss vss nch_18ud12_mac l=800n w=800n m=2 nf=1
MM0<29> vss vdd vss vss nch_18ud12_mac l=800n w=800n m=2 nf=1
MM0<30> vss vdd vss vss nch_18ud12_mac l=800n w=800n m=2 nf=1
MM0<31> vss vdd vss vss nch_18ud12_mac l=800n w=800n m=2 nf=1
MM1<0> vss vdd vss vss nch_18ud12_mac l=800n w=450.0n m=2 nf=1
MM1<1> vss vdd vss vss nch_18ud12_mac l=800n w=450.0n m=2 nf=1
MM1<2> vss vdd vss vss nch_18ud12_mac l=800n w=450.0n m=2 nf=1
MM1<3> vss vdd vss vss nch_18ud12_mac l=800n w=450.0n m=2 nf=1
MM1<4> vss vdd vss vss nch_18ud12_mac l=800n w=450.0n m=2 nf=1
MM1<5> vss vdd vss vss nch_18ud12_mac l=800n w=450.0n m=2 nf=1
MM1<6> vss vdd vss vss nch_18ud12_mac l=800n w=450.0n m=2 nf=1
MM1<7> vss vdd vss vss nch_18ud12_mac l=800n w=450.0n m=2 nf=1
MM1<8> vss vdd vss vss nch_18ud12_mac l=800n w=450.0n m=2 nf=1
MM1<9> vss vdd vss vss nch_18ud12_mac l=800n w=450.0n m=2 nf=1
MM1<10> vss vdd vss vss nch_18ud12_mac l=800n w=450.0n m=2 nf=1
MM1<11> vss vdd vss vss nch_18ud12_mac l=800n w=450.0n m=2 nf=1
MM1<12> vss vdd vss vss nch_18ud12_mac l=800n w=450.0n m=2 nf=1
MM1<13> vss vdd vss vss nch_18ud12_mac l=800n w=450.0n m=2 nf=1
MM1<14> vss vdd vss vss nch_18ud12_mac l=800n w=450.0n m=2 nf=1
MM1<15> vss vdd vss vss nch_18ud12_mac l=800n w=450.0n m=2 nf=1
Xi288 net826 vdd vss net847 / physpineu_INVD2BWP7T30P140
Xi287 net825 vdd vss net846 / physpineu_INVD2BWP7T30P140
Xi282 net827 vdd vss net848 / physpineu_INVD2BWP7T30P140
Xi279 net778 vdd vss net799 / physpineu_INVD2BWP7T30P140
Xi278 net779 vdd vss net798 / physpineu_INVD2BWP7T30P140
Xi273 net777 vdd vss net800 / physpineu_INVD2BWP7T30P140
Xi270 net730 vdd vss net751 / physpineu_INVD2BWP7T30P140
Xi269 net729 vdd vss net750 / physpineu_INVD2BWP7T30P140
Xi264 net731 vdd vss net752 / physpineu_INVD2BWP7T30P140
Xi138 net265 vdd vss net262 / physpineu_INVD2BWP7T30P140
Xi142 net263 vdd vss net264 / physpineu_INVD2BWP7T30P140
Xi145 net259 vdd vss net266 / physpineu_INVD2BWP7T30P140
Xi78<1> net267[1] vdd vss net280[1] / physpineu_INVD2BWP7T30P140
Xi78<0> net267[0] vdd vss net280[0] / physpineu_INVD2BWP7T30P140
Xi77<17> net268[17] vdd vss net281[17] / physpineu_INVD2BWP7T30P140
Xi77<16> net268[16] vdd vss net281[16] / physpineu_INVD2BWP7T30P140
Xi77<15> net268[15] vdd vss net281[15] / physpineu_INVD2BWP7T30P140
Xi77<14> net268[14] vdd vss net281[14] / physpineu_INVD2BWP7T30P140
Xi77<13> net268[13] vdd vss net281[13] / physpineu_INVD2BWP7T30P140
Xi77<12> net268[12] vdd vss net281[12] / physpineu_INVD2BWP7T30P140
Xi77<11> net268[11] vdd vss net281[11] / physpineu_INVD2BWP7T30P140
Xi77<10> net268[10] vdd vss net281[10] / physpineu_INVD2BWP7T30P140
Xi77<9> net268[9] vdd vss net281[9] / physpineu_INVD2BWP7T30P140
Xi77<8> net268[8] vdd vss net281[8] / physpineu_INVD2BWP7T30P140
Xi77<7> net268[7] vdd vss net281[7] / physpineu_INVD2BWP7T30P140
Xi77<6> net268[6] vdd vss net281[6] / physpineu_INVD2BWP7T30P140
Xi77<5> net268[5] vdd vss net281[5] / physpineu_INVD2BWP7T30P140
Xi77<4> net268[4] vdd vss net281[4] / physpineu_INVD2BWP7T30P140
Xi77<3> net268[3] vdd vss net281[3] / physpineu_INVD2BWP7T30P140
Xi77<2> net268[2] vdd vss net281[2] / physpineu_INVD2BWP7T30P140
Xi77<1> net268[1] vdd vss net281[1] / physpineu_INVD2BWP7T30P140
Xi77<0> net268[0] vdd vss net281[0] / physpineu_INVD2BWP7T30P140
Xi76<17> net269[17] vdd vss net282[17] / physpineu_INVD2BWP7T30P140
Xi76<16> net269[16] vdd vss net282[16] / physpineu_INVD2BWP7T30P140
Xi76<15> net269[15] vdd vss net282[15] / physpineu_INVD2BWP7T30P140
Xi76<14> net269[14] vdd vss net282[14] / physpineu_INVD2BWP7T30P140
Xi76<13> net269[13] vdd vss net282[13] / physpineu_INVD2BWP7T30P140
Xi76<12> net269[12] vdd vss net282[12] / physpineu_INVD2BWP7T30P140
Xi76<11> net269[11] vdd vss net282[11] / physpineu_INVD2BWP7T30P140
Xi76<10> net269[10] vdd vss net282[10] / physpineu_INVD2BWP7T30P140
Xi76<9> net269[9] vdd vss net282[9] / physpineu_INVD2BWP7T30P140
Xi76<8> net269[8] vdd vss net282[8] / physpineu_INVD2BWP7T30P140
Xi76<7> net269[7] vdd vss net282[7] / physpineu_INVD2BWP7T30P140
Xi76<6> net269[6] vdd vss net282[6] / physpineu_INVD2BWP7T30P140
Xi76<5> net269[5] vdd vss net282[5] / physpineu_INVD2BWP7T30P140
Xi76<4> net269[4] vdd vss net282[4] / physpineu_INVD2BWP7T30P140
Xi76<3> net269[3] vdd vss net282[3] / physpineu_INVD2BWP7T30P140
Xi76<2> net269[2] vdd vss net282[2] / physpineu_INVD2BWP7T30P140
Xi76<1> net269[1] vdd vss net282[1] / physpineu_INVD2BWP7T30P140
Xi76<0> net269[0] vdd vss net282[0] / physpineu_INVD2BWP7T30P140
Xi63<17> net273[17] vdd vss net286[17] / physpineu_INVD2BWP7T30P140
Xi63<16> net273[16] vdd vss net286[16] / physpineu_INVD2BWP7T30P140
Xi63<15> net273[15] vdd vss net286[15] / physpineu_INVD2BWP7T30P140
Xi63<14> net273[14] vdd vss net286[14] / physpineu_INVD2BWP7T30P140
Xi63<13> net273[13] vdd vss net286[13] / physpineu_INVD2BWP7T30P140
Xi63<12> net273[12] vdd vss net286[12] / physpineu_INVD2BWP7T30P140
Xi63<11> net273[11] vdd vss net286[11] / physpineu_INVD2BWP7T30P140
Xi63<10> net273[10] vdd vss net286[10] / physpineu_INVD2BWP7T30P140
Xi63<9> net273[9] vdd vss net286[9] / physpineu_INVD2BWP7T30P140
Xi63<8> net273[8] vdd vss net286[8] / physpineu_INVD2BWP7T30P140
Xi63<7> net273[7] vdd vss net286[7] / physpineu_INVD2BWP7T30P140
Xi63<6> net273[6] vdd vss net286[6] / physpineu_INVD2BWP7T30P140
Xi63<5> net273[5] vdd vss net286[5] / physpineu_INVD2BWP7T30P140
Xi63<4> net273[4] vdd vss net286[4] / physpineu_INVD2BWP7T30P140
Xi63<3> net273[3] vdd vss net286[3] / physpineu_INVD2BWP7T30P140
Xi63<2> net273[2] vdd vss net286[2] / physpineu_INVD2BWP7T30P140
Xi63<1> net273[1] vdd vss net286[1] / physpineu_INVD2BWP7T30P140
Xi63<0> net273[0] vdd vss net286[0] / physpineu_INVD2BWP7T30P140
Xi62<17> net270[17] vdd vss net283[17] / physpineu_INVD2BWP7T30P140
Xi62<16> net270[16] vdd vss net283[16] / physpineu_INVD2BWP7T30P140
Xi62<15> net270[15] vdd vss net283[15] / physpineu_INVD2BWP7T30P140
Xi62<14> net270[14] vdd vss net283[14] / physpineu_INVD2BWP7T30P140
Xi62<13> net270[13] vdd vss net283[13] / physpineu_INVD2BWP7T30P140
Xi62<12> net270[12] vdd vss net283[12] / physpineu_INVD2BWP7T30P140
Xi62<11> net270[11] vdd vss net283[11] / physpineu_INVD2BWP7T30P140
Xi62<10> net270[10] vdd vss net283[10] / physpineu_INVD2BWP7T30P140
Xi62<9> net270[9] vdd vss net283[9] / physpineu_INVD2BWP7T30P140
Xi62<8> net270[8] vdd vss net283[8] / physpineu_INVD2BWP7T30P140
Xi62<7> net270[7] vdd vss net283[7] / physpineu_INVD2BWP7T30P140
Xi62<6> net270[6] vdd vss net283[6] / physpineu_INVD2BWP7T30P140
Xi62<5> net270[5] vdd vss net283[5] / physpineu_INVD2BWP7T30P140
Xi62<4> net270[4] vdd vss net283[4] / physpineu_INVD2BWP7T30P140
Xi62<3> net270[3] vdd vss net283[3] / physpineu_INVD2BWP7T30P140
Xi62<2> net270[2] vdd vss net283[2] / physpineu_INVD2BWP7T30P140
Xi62<1> net270[1] vdd vss net283[1] / physpineu_INVD2BWP7T30P140
Xi62<0> net270[0] vdd vss net283[0] / physpineu_INVD2BWP7T30P140
Xi61<17> net271[17] vdd vss net284[17] / physpineu_INVD2BWP7T30P140
Xi61<16> net271[16] vdd vss net284[16] / physpineu_INVD2BWP7T30P140
Xi61<15> net271[15] vdd vss net284[15] / physpineu_INVD2BWP7T30P140
Xi61<14> net271[14] vdd vss net284[14] / physpineu_INVD2BWP7T30P140
Xi61<13> net271[13] vdd vss net284[13] / physpineu_INVD2BWP7T30P140
Xi61<12> net271[12] vdd vss net284[12] / physpineu_INVD2BWP7T30P140
Xi61<11> net271[11] vdd vss net284[11] / physpineu_INVD2BWP7T30P140
Xi61<10> net271[10] vdd vss net284[10] / physpineu_INVD2BWP7T30P140
Xi61<9> net271[9] vdd vss net284[9] / physpineu_INVD2BWP7T30P140
Xi61<8> net271[8] vdd vss net284[8] / physpineu_INVD2BWP7T30P140
Xi61<7> net271[7] vdd vss net284[7] / physpineu_INVD2BWP7T30P140
Xi61<6> net271[6] vdd vss net284[6] / physpineu_INVD2BWP7T30P140
Xi61<5> net271[5] vdd vss net284[5] / physpineu_INVD2BWP7T30P140
Xi61<4> net271[4] vdd vss net284[4] / physpineu_INVD2BWP7T30P140
Xi61<3> net271[3] vdd vss net284[3] / physpineu_INVD2BWP7T30P140
Xi61<2> net271[2] vdd vss net284[2] / physpineu_INVD2BWP7T30P140
Xi61<1> net271[1] vdd vss net284[1] / physpineu_INVD2BWP7T30P140
Xi61<0> net271[0] vdd vss net284[0] / physpineu_INVD2BWP7T30P140
Xi60<17> net272[17] vdd vss net285[17] / physpineu_INVD2BWP7T30P140
Xi60<16> net272[16] vdd vss net285[16] / physpineu_INVD2BWP7T30P140
Xi60<15> net272[15] vdd vss net285[15] / physpineu_INVD2BWP7T30P140
Xi60<14> net272[14] vdd vss net285[14] / physpineu_INVD2BWP7T30P140
Xi60<13> net272[13] vdd vss net285[13] / physpineu_INVD2BWP7T30P140
Xi60<12> net272[12] vdd vss net285[12] / physpineu_INVD2BWP7T30P140
Xi60<11> net272[11] vdd vss net285[11] / physpineu_INVD2BWP7T30P140
Xi60<10> net272[10] vdd vss net285[10] / physpineu_INVD2BWP7T30P140
Xi60<9> net272[9] vdd vss net285[9] / physpineu_INVD2BWP7T30P140
Xi60<8> net272[8] vdd vss net285[8] / physpineu_INVD2BWP7T30P140
Xi60<7> net272[7] vdd vss net285[7] / physpineu_INVD2BWP7T30P140
Xi60<6> net272[6] vdd vss net285[6] / physpineu_INVD2BWP7T30P140
Xi60<5> net272[5] vdd vss net285[5] / physpineu_INVD2BWP7T30P140
Xi60<4> net272[4] vdd vss net285[4] / physpineu_INVD2BWP7T30P140
Xi60<3> net272[3] vdd vss net285[3] / physpineu_INVD2BWP7T30P140
Xi60<2> net272[2] vdd vss net285[2] / physpineu_INVD2BWP7T30P140
Xi60<1> net272[1] vdd vss net285[1] / physpineu_INVD2BWP7T30P140
Xi60<0> net272[0] vdd vss net285[0] / physpineu_INVD2BWP7T30P140
Xi59<17> net274[17] vdd vss net287[17] / physpineu_INVD2BWP7T30P140
Xi59<16> net274[16] vdd vss net287[16] / physpineu_INVD2BWP7T30P140
Xi59<15> net274[15] vdd vss net287[15] / physpineu_INVD2BWP7T30P140
Xi59<14> net274[14] vdd vss net287[14] / physpineu_INVD2BWP7T30P140
Xi59<13> net274[13] vdd vss net287[13] / physpineu_INVD2BWP7T30P140
Xi59<12> net274[12] vdd vss net287[12] / physpineu_INVD2BWP7T30P140
Xi59<11> net274[11] vdd vss net287[11] / physpineu_INVD2BWP7T30P140
Xi59<10> net274[10] vdd vss net287[10] / physpineu_INVD2BWP7T30P140
Xi59<9> net274[9] vdd vss net287[9] / physpineu_INVD2BWP7T30P140
Xi59<8> net274[8] vdd vss net287[8] / physpineu_INVD2BWP7T30P140
Xi59<7> net274[7] vdd vss net287[7] / physpineu_INVD2BWP7T30P140
Xi59<6> net274[6] vdd vss net287[6] / physpineu_INVD2BWP7T30P140
Xi59<5> net274[5] vdd vss net287[5] / physpineu_INVD2BWP7T30P140
Xi59<4> net274[4] vdd vss net287[4] / physpineu_INVD2BWP7T30P140
Xi59<3> net274[3] vdd vss net287[3] / physpineu_INVD2BWP7T30P140
Xi59<2> net274[2] vdd vss net287[2] / physpineu_INVD2BWP7T30P140
Xi59<1> net274[1] vdd vss net287[1] / physpineu_INVD2BWP7T30P140
Xi59<0> net274[0] vdd vss net287[0] / physpineu_INVD2BWP7T30P140
Xi51<17> net276[17] vdd vss net289[17] / physpineu_INVD2BWP7T30P140
Xi51<16> net276[16] vdd vss net289[16] / physpineu_INVD2BWP7T30P140
Xi51<15> net276[15] vdd vss net289[15] / physpineu_INVD2BWP7T30P140
Xi51<14> net276[14] vdd vss net289[14] / physpineu_INVD2BWP7T30P140
Xi51<13> net276[13] vdd vss net289[13] / physpineu_INVD2BWP7T30P140
Xi51<12> net276[12] vdd vss net289[12] / physpineu_INVD2BWP7T30P140
Xi51<11> net276[11] vdd vss net289[11] / physpineu_INVD2BWP7T30P140
Xi51<10> net276[10] vdd vss net289[10] / physpineu_INVD2BWP7T30P140
Xi51<9> net276[9] vdd vss net289[9] / physpineu_INVD2BWP7T30P140
Xi51<8> net276[8] vdd vss net289[8] / physpineu_INVD2BWP7T30P140
Xi51<7> net276[7] vdd vss net289[7] / physpineu_INVD2BWP7T30P140
Xi51<6> net276[6] vdd vss net289[6] / physpineu_INVD2BWP7T30P140
Xi51<5> net276[5] vdd vss net289[5] / physpineu_INVD2BWP7T30P140
Xi51<4> net276[4] vdd vss net289[4] / physpineu_INVD2BWP7T30P140
Xi51<3> net276[3] vdd vss net289[3] / physpineu_INVD2BWP7T30P140
Xi51<2> net276[2] vdd vss net289[2] / physpineu_INVD2BWP7T30P140
Xi51<1> net276[1] vdd vss net289[1] / physpineu_INVD2BWP7T30P140
Xi51<0> net276[0] vdd vss net289[0] / physpineu_INVD2BWP7T30P140
Xi46<17> net278[17] vdd vss net291[17] / physpineu_INVD2BWP7T30P140
Xi46<16> net278[16] vdd vss net291[16] / physpineu_INVD2BWP7T30P140
Xi46<15> net278[15] vdd vss net291[15] / physpineu_INVD2BWP7T30P140
Xi46<14> net278[14] vdd vss net291[14] / physpineu_INVD2BWP7T30P140
Xi46<13> net278[13] vdd vss net291[13] / physpineu_INVD2BWP7T30P140
Xi46<12> net278[12] vdd vss net291[12] / physpineu_INVD2BWP7T30P140
Xi46<11> net278[11] vdd vss net291[11] / physpineu_INVD2BWP7T30P140
Xi46<10> net278[10] vdd vss net291[10] / physpineu_INVD2BWP7T30P140
Xi46<9> net278[9] vdd vss net291[9] / physpineu_INVD2BWP7T30P140
Xi46<8> net278[8] vdd vss net291[8] / physpineu_INVD2BWP7T30P140
Xi46<7> net278[7] vdd vss net291[7] / physpineu_INVD2BWP7T30P140
Xi46<6> net278[6] vdd vss net291[6] / physpineu_INVD2BWP7T30P140
Xi46<5> net278[5] vdd vss net291[5] / physpineu_INVD2BWP7T30P140
Xi46<4> net278[4] vdd vss net291[4] / physpineu_INVD2BWP7T30P140
Xi46<3> net278[3] vdd vss net291[3] / physpineu_INVD2BWP7T30P140
Xi46<2> net278[2] vdd vss net291[2] / physpineu_INVD2BWP7T30P140
Xi46<1> net278[1] vdd vss net291[1] / physpineu_INVD2BWP7T30P140
Xi46<0> net278[0] vdd vss net291[0] / physpineu_INVD2BWP7T30P140
Xi58<15> net275[15] vdd vss net288[15] / physpineu_INVD2BWP7T30P140
Xi58<14> net275[14] vdd vss net288[14] / physpineu_INVD2BWP7T30P140
Xi58<13> net275[13] vdd vss net288[13] / physpineu_INVD2BWP7T30P140
Xi58<12> net275[12] vdd vss net288[12] / physpineu_INVD2BWP7T30P140
Xi58<11> net275[11] vdd vss net288[11] / physpineu_INVD2BWP7T30P140
Xi58<10> net275[10] vdd vss net288[10] / physpineu_INVD2BWP7T30P140
Xi58<9> net275[9] vdd vss net288[9] / physpineu_INVD2BWP7T30P140
Xi58<8> net275[8] vdd vss net288[8] / physpineu_INVD2BWP7T30P140
Xi58<7> net275[7] vdd vss net288[7] / physpineu_INVD2BWP7T30P140
Xi58<6> net275[6] vdd vss net288[6] / physpineu_INVD2BWP7T30P140
Xi58<5> net275[5] vdd vss net288[5] / physpineu_INVD2BWP7T30P140
Xi58<4> net275[4] vdd vss net288[4] / physpineu_INVD2BWP7T30P140
Xi58<3> net275[3] vdd vss net288[3] / physpineu_INVD2BWP7T30P140
Xi58<2> net275[2] vdd vss net288[2] / physpineu_INVD2BWP7T30P140
Xi58<1> net275[1] vdd vss net288[1] / physpineu_INVD2BWP7T30P140
Xi58<0> net275[0] vdd vss net288[0] / physpineu_INVD2BWP7T30P140
Xi48<17> net277[17] vdd vss net290[17] / physpineu_INVD2BWP7T30P140
Xi48<16> net277[16] vdd vss net290[16] / physpineu_INVD2BWP7T30P140
Xi48<15> net277[15] vdd vss net290[15] / physpineu_INVD2BWP7T30P140
Xi48<14> net277[14] vdd vss net290[14] / physpineu_INVD2BWP7T30P140
Xi48<13> net277[13] vdd vss net290[13] / physpineu_INVD2BWP7T30P140
Xi48<12> net277[12] vdd vss net290[12] / physpineu_INVD2BWP7T30P140
Xi48<11> net277[11] vdd vss net290[11] / physpineu_INVD2BWP7T30P140
Xi48<10> net277[10] vdd vss net290[10] / physpineu_INVD2BWP7T30P140
Xi48<9> net277[9] vdd vss net290[9] / physpineu_INVD2BWP7T30P140
Xi48<8> net277[8] vdd vss net290[8] / physpineu_INVD2BWP7T30P140
Xi48<7> net277[7] vdd vss net290[7] / physpineu_INVD2BWP7T30P140
Xi48<6> net277[6] vdd vss net290[6] / physpineu_INVD2BWP7T30P140
Xi48<5> net277[5] vdd vss net290[5] / physpineu_INVD2BWP7T30P140
Xi48<4> net277[4] vdd vss net290[4] / physpineu_INVD2BWP7T30P140
Xi48<3> net277[3] vdd vss net290[3] / physpineu_INVD2BWP7T30P140
Xi48<2> net277[2] vdd vss net290[2] / physpineu_INVD2BWP7T30P140
Xi48<1> net277[1] vdd vss net290[1] / physpineu_INVD2BWP7T30P140
Xi48<0> net277[0] vdd vss net290[0] / physpineu_INVD2BWP7T30P140
Xi1<17> net279[17] vdd vss net292[17] / physpineu_INVD2BWP7T30P140
Xi1<16> net279[16] vdd vss net292[16] / physpineu_INVD2BWP7T30P140
Xi1<15> net279[15] vdd vss net292[15] / physpineu_INVD2BWP7T30P140
Xi1<14> net279[14] vdd vss net292[14] / physpineu_INVD2BWP7T30P140
Xi1<13> net279[13] vdd vss net292[13] / physpineu_INVD2BWP7T30P140
Xi1<12> net279[12] vdd vss net292[12] / physpineu_INVD2BWP7T30P140
Xi1<11> net279[11] vdd vss net292[11] / physpineu_INVD2BWP7T30P140
Xi1<10> net279[10] vdd vss net292[10] / physpineu_INVD2BWP7T30P140
Xi1<9> net279[9] vdd vss net292[9] / physpineu_INVD2BWP7T30P140
Xi1<8> net279[8] vdd vss net292[8] / physpineu_INVD2BWP7T30P140
Xi1<7> net279[7] vdd vss net292[7] / physpineu_INVD2BWP7T30P140
Xi1<6> net279[6] vdd vss net292[6] / physpineu_INVD2BWP7T30P140
Xi1<5> net279[5] vdd vss net292[5] / physpineu_INVD2BWP7T30P140
Xi1<4> net279[4] vdd vss net292[4] / physpineu_INVD2BWP7T30P140
Xi1<3> net279[3] vdd vss net292[3] / physpineu_INVD2BWP7T30P140
Xi1<2> net279[2] vdd vss net292[2] / physpineu_INVD2BWP7T30P140
Xi1<1> net279[1] vdd vss net292[1] / physpineu_INVD2BWP7T30P140
Xi1<0> net279[0] vdd vss net292[0] / physpineu_INVD2BWP7T30P140
Xi326 net3 vdd vss ls_en_asic_buf15 / physpineu_BUFFD16BWP7T30P140
Xi308 net0142 vdd vss ls_en_asic_buf14 / physpineu_BUFFD16BWP7T30P140
Xi156 net0139 vdd vss ls_en_asic_buf3 / physpineu_BUFFD16BWP7T30P140
Xi154 net0132 vdd vss net0139 / physpineu_BUFFD16BWP7T30P140
Xi168 net0142 vdd vss ls_en_asic_buf13 / physpineu_BUFFD16BWP7T30P140
Xi167 net0132 vdd vss net0142 / physpineu_BUFFD16BWP7T30P140
Xi158 net0141 vdd vss ls_en_asic_buf7 / physpineu_BUFFD16BWP7T30P140
Xi157 net0132 vdd vss net0141 / physpineu_BUFFD16BWP7T30P140
Xi160 net0141 vdd vss ls_en_asic_buf5 / physpineu_BUFFD16BWP7T30P140
Xi159 net0141 vdd vss ls_en_asic_buf6 / physpineu_BUFFD16BWP7T30P140
Xi162 net0132 vdd vss net3 / physpineu_BUFFD16BWP7T30P140
Xi161 net0139 vdd vss ls_en_asic_buf4 / physpineu_BUFFD16BWP7T30P140
Xi164 net0141 vdd vss ls_en_asic_buf8 / physpineu_BUFFD16BWP7T30P140
Xi163 net3 vdd vss ls_en_asic_buf11 / physpineu_BUFFD16BWP7T30P140
Xi166 net3 vdd vss ls_en_asic_buf10 / physpineu_BUFFD16BWP7T30P140
Xi165 net3 vdd vss ls_en_asic_buf9 / physpineu_BUFFD16BWP7T30P140
Xi169 net0142 vdd vss ls_en_asic_buf12 / physpineu_BUFFD16BWP7T30P140
Xi111 net0139 vdd vss ls_en_asic_buf1 / physpineu_BUFFD16BWP7T30P140
Xi227 net0139 vdd vss ls_en_asic_buf0 / physpineu_BUFFD16BWP7T30P140
Xi155 net0139 vdd vss ls_en_asic_buf2 / physpineu_BUFFD16BWP7T30P140
Xi240 ls_en_asic vdd vss net0289 / physpineu_BUFFD4BWP7T30P140
Xi223 D1_DUMP_READY ls_en_asic_buf13 D1_DUMP_READY_ASIC ls_en_asic_buf13
+ net555 vdd vdd_array vss vss_array / physpineu_asic_in_latch
Xi221 D1_STOPWATCH_RINGO ls_en_asic_buf13 D1_STOPWATCH_RINGO_ASIC
+ ls_en_asic_buf13 net558 vdd vdd_array vss vss_array / physpineu_asic_in_latch
Xi219<1> D1_OSC_TM_RES[1] ls_en_asic_buf14 D1_OSC_TM_RES_ASIC[1]
+ ls_en_asic_buf14 net4[1] vdd vdd_array vss vss_array / physpineu_asic_in_latch
Xi219<0> D1_OSC_TM_RES[0] ls_en_asic_buf14 D1_OSC_TM_RES_ASIC[0]
+ ls_en_asic_buf14 net4[0] vdd vdd_array vss vss_array / physpineu_asic_in_latch
Xi262 D3_DUMP_READY ls_en_asic_buf13 D3_DUMP_READY_ASIC ls_en_asic_buf13
+ net627 vdd vdd_array vss vss_array / physpineu_asic_in_latch
Xi260 D3_STOPWATCH_RINGO ls_en_asic_buf13 D3_STOPWATCH_RINGO_ASIC
+ ls_en_asic_buf13 net702 vdd vdd_array vss vss_array / physpineu_asic_in_latch
Xi258<1> D3_OSC_TM_RES[1] ls_en_asic_buf14 D3_OSC_TM_RES_ASIC[1]
+ ls_en_asic_buf14 net6[1] vdd vdd_array vss vss_array / physpineu_asic_in_latch
Xi258<0> D3_OSC_TM_RES[0] ls_en_asic_buf14 D3_OSC_TM_RES_ASIC[0]
+ ls_en_asic_buf14 net6[0] vdd vdd_array vss vss_array / physpineu_asic_in_latch
Xi232 D2_DUMP_READY ls_en_asic_buf13 D2_DUMP_READY_ASIC ls_en_asic_buf13 net2
+ vdd vdd_array vss vss_array / physpineu_asic_in_latch
Xi231 D2_STOPWATCH_RINGO ls_en_asic_buf13 D2_STOPWATCH_RINGO_ASIC
+ ls_en_asic_buf13 net573 vdd vdd_array vss vss_array / physpineu_asic_in_latch
Xi128 DUMP_READY ls_en_asic_buf13 DUMP_READY_ASIC ls_en_asic_buf13 net260 vdd
+ vdd_array vss vss_array / physpineu_asic_in_latch
Xi229<1> D2_OSC_TM_RES[1] ls_en_asic_buf14 D2_OSC_TM_RES_ASIC[1]
+ ls_en_asic_buf14 net5[1] vdd vdd_array vss vss_array / physpineu_asic_in_latch
Xi229<0> D2_OSC_TM_RES[0] ls_en_asic_buf14 D2_OSC_TM_RES_ASIC[0]
+ ls_en_asic_buf14 net5[0] vdd vdd_array vss vss_array / physpineu_asic_in_latch
Xi134 STOPWATCH_RINGO ls_en_asic_buf13 STOPWATCH_RINGO_ASIC ls_en_asic_buf13
+ net258 vdd vdd_array vss vss_array / physpineu_asic_in_latch
Xi135<1> OSC_TM_RES[1] ls_en_asic_buf14 OSC_TM_RES_ASIC[1] ls_en_asic_buf14
+ net1[1] vdd vdd_array vss vss_array / physpineu_asic_in_latch
Xi135<0> OSC_TM_RES[0] ls_en_asic_buf14 OSC_TM_RES_ASIC[0] ls_en_asic_buf14
+ net1[0] vdd vdd_array vss vss_array / physpineu_asic_in_latch
Xi241 net0289 vdd vss net0132 / physpineu_BUFFD12BWP7T30P140
.ENDS
